* testlib

* Device subcircuits
*
.subckt rsil n1 n2 l=1e-6 w=1e-6
.param rsil_res={l*7.0/w}
Rres n1 n2 r={rsil_res} rsil l=l w=w
.ends rsil

.subckt rppd n1 n2 l=1e-6 w=1e-6
.param rppd_res={l*260.0/w}
Rres n1 n2 r={rppd_res} rppd l=l w=w
.ends rppd

.subckt dantenna an cat params: w=0.48e-6 l=0.48e-6
Ddio an cat dantenna a=(w*l) p=(2*(w + l))
.ends dantenna

.subckt dpantenna an cat params: w=0.48e-6 l=0.48e-6
Ddio an cat dpantenna a=(w*l) p=(2*(w + l))
.ends dpantenna

.subckt sg13_lv_nmos s g d b params: l=0.13e-6 w=0.15e-6
Mtrans s g d b sg13_lv_nmos l=l w=w
.ends sg13_lv_nmos

.subckt sg13_lv_pmos s g d b params: l=0.13e-6 w=0.15e-6
Mtrans s g d b sg13_lv_pmos l=l w=w
.ends sg13_lv_pmos

.subckt sg13_hv_nmos s g d b params: l=0.45e-6 w=0.3e-6
Mtrans s g d b sg13_hv_nmos l=l w=w
.ends sg13_hv_nmos

.subckt sg13_hv_pmos s g d b params: l=0.45e-6 w=0.3e-6
Mtrans s g d b sg13_hv_pmos l=l w=w
.ends sg13_hv_pmos

* Library cells
*
.subckt BondPad pad
.ends BondPad

.subckt sg13g2_IOPadIn pad p2c
.ends sg13g2_IOPadIn

.subckt sg13g2_IOPadOut30mA pad c2p
.ends sg13g2_IOPadOut30mA

.subckt sg13g2_IOPadAnalog pad pad_core
.ends sg13g2_IOPadAnalog

.subckt sg13g2_Corner
.ends sg13g2_Corner

.subckt sg13g2_Filler2000
.ends sg13g2_Filler2000

.subckt sg13g2_Filler4000
.ends sg13g2_Filler4000

.subckt sg13g2_Filler10000
.ends sg13g2_Filler10000

.subckt sg13g2_Filler20000
Xfill1  sg13g2_Filler10000
Xfill2  sg13g2_Filler10000
.ends sg13g2_Filler20000

.subckt sg13g2_IOPadVss pad
.ends sg13g2_IOPadVss

.subckt sg13g2_IOPadVdd pad
.ends sg13g2_IOPadVdd

.subckt sg13g2_IOPadIOVss pad
.ends sg13g2_IOPadIOVss

.subckt sg13g2_IOPadIOVdd pad
.ends sg13g2_IOPadIOVdd

.subckt sg13g2_DCIO10000 vss vdd iovss iovdd
Xbp_vss vss BondPad
Xio_vss vss sg13g2_IOPadVss
Xbp_vdd vdd BondPad
Xio_vdd vdd sg13g2_IOPadVdd
Xbp_iovss iovss BondPad
Xio_iovss iovss sg13g2_IOPadIOVss
Xbp_iovdd iovdd BondPad
Xio_iovdd iovdd sg13g2_IOPadIOVdd
Xfill_start  sg13g2_Filler10000
Xfill_vss  sg13g2_Filler10000
Xfill_vdd  sg13g2_Filler10000
Xfill_iovss  sg13g2_Filler10000
Xfill_iovdd  sg13g2_Filler10000
.ends sg13g2_DCIO10000

.subckt SP6T1Cell vss substrate vdd nwell wl bl bl_n
Xpu1 vdd bit_n bit nwell sg13_lv_pmos l=1.3e-07 w=1.5e-07
Xpd1 bit bit_n vss substrate sg13_lv_nmos l=1.3e-07 w=2e-07
Xpu2 vdd bit bit_n nwell sg13_lv_pmos l=1.3e-07 w=1.5e-07
Xpd2 bit_n bit vss substrate sg13_lv_nmos l=1.3e-07 w=2e-07
Xpg1 bit wl bl substrate sg13_lv_nmos l=1.3e-07 w=2e-07
Xpg2 bit_n wl bl_n substrate sg13_lv_nmos l=1.3e-07 w=2e-07
.ends SP6T1Cell

.subckt SP6T1Array_2X1 vss substrate vdd nwell wl[0] wl[1] bl[0] bl_n[0]
Xinst0x0 vss substrate vdd nwell wl[0] bl[0] bl_n[0] SP6T1Cell
Xinst1x0 vss substrate vdd nwell wl[1] bl[0] bl_n[0] SP6T1Cell
.ends SP6T1Array_2X1

.subckt SP6T1Array_2X2 vss substrate vdd nwell wl[0] wl[1] bl[0] bl_n[0] bl[1] bl_n[1]
Xinst0x0 vss substrate vdd nwell wl[0] wl[1] bl[0] bl_n[0] SP6T1Array_2X1
Xinst0x1 vss substrate vdd nwell wl[0] wl[1] bl[1] bl_n[1] SP6T1Array_2X1
.ends SP6T1Array_2X2

.subckt SP6T1Array_4X2 vss substrate vdd nwell wl[0] wl[1] wl[2] wl[3] bl[0] bl_n[0] bl[1] bl_n[1]
Xinst0x0 vss substrate vdd nwell wl[0] wl[1] bl[0] bl_n[0] bl[1] bl_n[1] SP6T1Array_2X2
Xinst1x0 vss substrate vdd nwell wl[2] wl[3] bl[0] bl_n[0] bl[1] bl_n[1] SP6T1Array_2X2
.ends SP6T1Array_4X2

.subckt SP6T1Array_4X4 vss substrate vdd nwell wl[0] wl[1] wl[2] wl[3] bl[0] bl_n[0] bl[1] bl_n[1] bl[2] bl_n[2] bl[3] bl_n[3]
Xinst0x0 vss substrate vdd nwell wl[0] wl[1] wl[2] wl[3] bl[0] bl_n[0] bl[1] bl_n[1] SP6T1Array_4X2
Xinst0x1 vss substrate vdd nwell wl[0] wl[1] wl[2] wl[3] bl[2] bl_n[2] bl[3] bl_n[3] SP6T1Array_4X2
.ends SP6T1Array_4X4

.subckt SP6T1Array_8X4 vss substrate vdd nwell wl[0] wl[1] wl[2] wl[3] wl[4] wl[5] wl[6] wl[7] bl[0] bl_n[0] bl[1] bl_n[1] bl[2] bl_n[2] bl[3] bl_n[3]
Xinst0x0 vss substrate vdd nwell wl[0] wl[1] wl[2] wl[3] bl[0] bl_n[0] bl[1] bl_n[1] bl[2] bl_n[2] bl[3] bl_n[3] SP6T1Array_4X4
Xinst1x0 vss substrate vdd nwell wl[4] wl[5] wl[6] wl[7] bl[0] bl_n[0] bl[1] bl_n[1] bl[2] bl_n[2] bl[3] bl_n[3] SP6T1Array_4X4
.ends SP6T1Array_8X4

.subckt SP6T1Array_8X8 vss substrate vdd nwell wl[0] wl[1] wl[2] wl[3] wl[4] wl[5] wl[6] wl[7] bl[0] bl_n[0] bl[1] bl_n[1] bl[2] bl_n[2] bl[3] bl_n[3] bl[4] bl_n[4] bl[5] bl_n[5] bl[6] bl_n[6] bl[7] bl_n[7]
Xinst0x0 vss substrate vdd nwell wl[0] wl[1] wl[2] wl[3] wl[4] wl[5] wl[6] wl[7] bl[0] bl_n[0] bl[1] bl_n[1] bl[2] bl_n[2] bl[3] bl_n[3] SP6T1Array_8X4
Xinst0x1 vss substrate vdd nwell wl[0] wl[1] wl[2] wl[3] wl[4] wl[5] wl[6] wl[7] bl[4] bl_n[4] bl[5] bl_n[5] bl[6] bl_n[6] bl[7] bl_n[7] SP6T1Array_8X4
.ends SP6T1Array_8X8

.subckt SP6T1Array_16X8 vss substrate vdd nwell wl[0] wl[1] wl[2] wl[3] wl[4] wl[5] wl[6] wl[7] wl[8] wl[9] wl[10] wl[11] wl[12] wl[13] wl[14] wl[15] bl[0] bl_n[0] bl[1] bl_n[1] bl[2] bl_n[2] bl[3] bl_n[3] bl[4] bl_n[4] bl[5] bl_n[5] bl[6] bl_n[6] bl[7] bl_n[7]
Xinst0x0 vss substrate vdd nwell wl[0] wl[1] wl[2] wl[3] wl[4] wl[5] wl[6] wl[7] bl[0] bl_n[0] bl[1] bl_n[1] bl[2] bl_n[2] bl[3] bl_n[3] bl[4] bl_n[4] bl[5] bl_n[5] bl[6] bl_n[6] bl[7] bl_n[7] SP6T1Array_8X8
Xinst1x0 vss substrate vdd nwell wl[8] wl[9] wl[10] wl[11] wl[12] wl[13] wl[14] wl[15] bl[0] bl_n[0] bl[1] bl_n[1] bl[2] bl_n[2] bl[3] bl_n[3] bl[4] bl_n[4] bl[5] bl_n[5] bl[6] bl_n[6] bl[7] bl_n[7] SP6T1Array_8X8
.ends SP6T1Array_16X8

.subckt SP6T1Array_16X16 vss substrate vdd nwell wl[0] wl[1] wl[2] wl[3] wl[4] wl[5] wl[6] wl[7] wl[8] wl[9] wl[10] wl[11] wl[12] wl[13] wl[14] wl[15] bl[0] bl_n[0] bl[1] bl_n[1] bl[2] bl_n[2] bl[3] bl_n[3] bl[4] bl_n[4] bl[5] bl_n[5] bl[6] bl_n[6] bl[7] bl_n[7] bl[8] bl_n[8] bl[9] bl_n[9] bl[10] bl_n[10] bl[11] bl_n[11] bl[12] bl_n[12] bl[13] bl_n[13] bl[14] bl_n[14] bl[15] bl_n[15]
Xinst0x0 vss substrate vdd nwell wl[0] wl[1] wl[2] wl[3] wl[4] wl[5] wl[6] wl[7] wl[8] wl[9] wl[10] wl[11] wl[12] wl[13] wl[14] wl[15] bl[0] bl_n[0] bl[1] bl_n[1] bl[2] bl_n[2] bl[3] bl_n[3] bl[4] bl_n[4] bl[5] bl_n[5] bl[6] bl_n[6] bl[7] bl_n[7] SP6T1Array_16X8
Xinst0x1 vss substrate vdd nwell wl[0] wl[1] wl[2] wl[3] wl[4] wl[5] wl[6] wl[7] wl[8] wl[9] wl[10] wl[11] wl[12] wl[13] wl[14] wl[15] bl[8] bl_n[8] bl[9] bl_n[9] bl[10] bl_n[10] bl[11] bl_n[11] bl[12] bl_n[12] bl[13] bl_n[13] bl[14] bl_n[14] bl[15] bl_n[15] SP6T1Array_16X8
.ends SP6T1Array_16X16

.subckt SP6T1Array_16X32 vss substrate vdd nwell wl[0] wl[1] wl[2] wl[3] wl[4] wl[5] wl[6] wl[7] wl[8] wl[9] wl[10] wl[11] wl[12] wl[13] wl[14] wl[15] bl[0] bl_n[0] bl[1] bl_n[1] bl[2] bl_n[2] bl[3] bl_n[3] bl[4] bl_n[4] bl[5] bl_n[5] bl[6] bl_n[6] bl[7] bl_n[7] bl[8] bl_n[8] bl[9] bl_n[9] bl[10] bl_n[10] bl[11] bl_n[11] bl[12] bl_n[12] bl[13] bl_n[13] bl[14] bl_n[14] bl[15] bl_n[15] bl[16] bl_n[16] bl[17] bl_n[17] bl[18] bl_n[18] bl[19] bl_n[19] bl[20] bl_n[20] bl[21] bl_n[21] bl[22] bl_n[22] bl[23] bl_n[23] bl[24] bl_n[24] bl[25] bl_n[25] bl[26] bl_n[26] bl[27] bl_n[27] bl[28] bl_n[28] bl[29] bl_n[29] bl[30] bl_n[30] bl[31] bl_n[31]
Xinst0x0 vss substrate vdd nwell wl[0] wl[1] wl[2] wl[3] wl[4] wl[5] wl[6] wl[7] wl[8] wl[9] wl[10] wl[11] wl[12] wl[13] wl[14] wl[15] bl[0] bl_n[0] bl[1] bl_n[1] bl[2] bl_n[2] bl[3] bl_n[3] bl[4] bl_n[4] bl[5] bl_n[5] bl[6] bl_n[6] bl[7] bl_n[7] bl[8] bl_n[8] bl[9] bl_n[9] bl[10] bl_n[10] bl[11] bl_n[11] bl[12] bl_n[12] bl[13] bl_n[13] bl[14] bl_n[14] bl[15] bl_n[15] SP6T1Array_16X16
Xinst0x1 vss substrate vdd nwell wl[0] wl[1] wl[2] wl[3] wl[4] wl[5] wl[6] wl[7] wl[8] wl[9] wl[10] wl[11] wl[12] wl[13] wl[14] wl[15] bl[16] bl_n[16] bl[17] bl_n[17] bl[18] bl_n[18] bl[19] bl_n[19] bl[20] bl_n[20] bl[21] bl_n[21] bl[22] bl_n[22] bl[23] bl_n[23] bl[24] bl_n[24] bl[25] bl_n[25] bl[26] bl_n[26] bl[27] bl_n[27] bl[28] bl_n[28] bl[29] bl_n[29] bl[30] bl_n[30] bl[31] bl_n[31] SP6T1Array_16X16
.ends SP6T1Array_16X32

.subckt SP6T1BulkConn vdd vss bl bl_n
.ends SP6T1BulkConn

.subckt SP6T1BulkConnRow_2C vss vdd bl[0] bl_n[0] bl[1] bl_n[1]
Xinst0 vdd vss bl[0] bl_n[0] SP6T1BulkConn
Xinst1 vdd vss bl[1] bl_n[1] SP6T1BulkConn
.ends SP6T1BulkConnRow_2C

.subckt SP6T1BulkConnRow_4C vss vdd bl[0] bl_n[0] bl[1] bl_n[1] bl[2] bl_n[2] bl[3] bl_n[3]
Xinst0 vss vdd bl[0] bl_n[0] bl[1] bl_n[1] SP6T1BulkConnRow_2C
Xinst1 vss vdd bl[2] bl_n[2] bl[3] bl_n[3] SP6T1BulkConnRow_2C
.ends SP6T1BulkConnRow_4C

.subckt SP6T1BulkConnRow_8C vss vdd bl[0] bl_n[0] bl[1] bl_n[1] bl[2] bl_n[2] bl[3] bl_n[3] bl[4] bl_n[4] bl[5] bl_n[5] bl[6] bl_n[6] bl[7] bl_n[7]
Xinst0 vss vdd bl[0] bl_n[0] bl[1] bl_n[1] bl[2] bl_n[2] bl[3] bl_n[3] SP6T1BulkConnRow_4C
Xinst1 vss vdd bl[4] bl_n[4] bl[5] bl_n[5] bl[6] bl_n[6] bl[7] bl_n[7] SP6T1BulkConnRow_4C
.ends SP6T1BulkConnRow_8C

.subckt SP6T1BulkConnRow_16C vss vdd bl[0] bl_n[0] bl[1] bl_n[1] bl[2] bl_n[2] bl[3] bl_n[3] bl[4] bl_n[4] bl[5] bl_n[5] bl[6] bl_n[6] bl[7] bl_n[7] bl[8] bl_n[8] bl[9] bl_n[9] bl[10] bl_n[10] bl[11] bl_n[11] bl[12] bl_n[12] bl[13] bl_n[13] bl[14] bl_n[14] bl[15] bl_n[15]
Xinst0 vss vdd bl[0] bl_n[0] bl[1] bl_n[1] bl[2] bl_n[2] bl[3] bl_n[3] bl[4] bl_n[4] bl[5] bl_n[5] bl[6] bl_n[6] bl[7] bl_n[7] SP6T1BulkConnRow_8C
Xinst1 vss vdd bl[8] bl_n[8] bl[9] bl_n[9] bl[10] bl_n[10] bl[11] bl_n[11] bl[12] bl_n[12] bl[13] bl_n[13] bl[14] bl_n[14] bl[15] bl_n[15] SP6T1BulkConnRow_8C
.ends SP6T1BulkConnRow_16C

.subckt SP6T1BulkConnRow_32C vss vdd bl[0] bl_n[0] bl[1] bl_n[1] bl[2] bl_n[2] bl[3] bl_n[3] bl[4] bl_n[4] bl[5] bl_n[5] bl[6] bl_n[6] bl[7] bl_n[7] bl[8] bl_n[8] bl[9] bl_n[9] bl[10] bl_n[10] bl[11] bl_n[11] bl[12] bl_n[12] bl[13] bl_n[13] bl[14] bl_n[14] bl[15] bl_n[15] bl[16] bl_n[16] bl[17] bl_n[17] bl[18] bl_n[18] bl[19] bl_n[19] bl[20] bl_n[20] bl[21] bl_n[21] bl[22] bl_n[22] bl[23] bl_n[23] bl[24] bl_n[24] bl[25] bl_n[25] bl[26] bl_n[26] bl[27] bl_n[27] bl[28] bl_n[28] bl[29] bl_n[29] bl[30] bl_n[30] bl[31] bl_n[31]
Xinst0 vss vdd bl[0] bl_n[0] bl[1] bl_n[1] bl[2] bl_n[2] bl[3] bl_n[3] bl[4] bl_n[4] bl[5] bl_n[5] bl[6] bl_n[6] bl[7] bl_n[7] bl[8] bl_n[8] bl[9] bl_n[9] bl[10] bl_n[10] bl[11] bl_n[11] bl[12] bl_n[12] bl[13] bl_n[13] bl[14] bl_n[14] bl[15] bl_n[15] SP6T1BulkConnRow_16C
Xinst1 vss vdd bl[16] bl_n[16] bl[17] bl_n[17] bl[18] bl_n[18] bl[19] bl_n[19] bl[20] bl_n[20] bl[21] bl_n[21] bl[22] bl_n[22] bl[23] bl_n[23] bl[24] bl_n[24] bl[25] bl_n[25] bl[26] bl_n[26] bl[27] bl_n[27] bl[28] bl_n[28] bl[29] bl_n[29] bl[30] bl_n[30] bl[31] bl_n[31] SP6T1BulkConnRow_16C
.ends SP6T1BulkConnRow_32C

.subckt SP6T1Array_32X32 vss vdd wl[0] wl[1] wl[2] wl[3] wl[4] wl[5] wl[6] wl[7] wl[8] wl[9] wl[10] wl[11] wl[12] wl[13] wl[14] wl[15] wl[16] wl[17] wl[18] wl[19] wl[20] wl[21] wl[22] wl[23] wl[24] wl[25] wl[26] wl[27] wl[28] wl[29] wl[30] wl[31] bl[0] bl_n[0] bl[1] bl_n[1] bl[2] bl_n[2] bl[3] bl_n[3] bl[4] bl_n[4] bl[5] bl_n[5] bl[6] bl_n[6] bl[7] bl_n[7] bl[8] bl_n[8] bl[9] bl_n[9] bl[10] bl_n[10] bl[11] bl_n[11] bl[12] bl_n[12] bl[13] bl_n[13] bl[14] bl_n[14] bl[15] bl_n[15] bl[16] bl_n[16] bl[17] bl_n[17] bl[18] bl_n[18] bl[19] bl_n[19] bl[20] bl_n[20] bl[21] bl_n[21] bl[22] bl_n[22] bl[23] bl_n[23] bl[24] bl_n[24] bl[25] bl_n[25] bl[26] bl_n[26] bl[27] bl_n[27] bl[28] bl_n[28] bl[29] bl_n[29] bl[30] bl_n[30] bl[31] bl_n[31]
Xinst0x0 vss vss vdd vdd wl[0] wl[1] wl[2] wl[3] wl[4] wl[5] wl[6] wl[7] wl[8] wl[9] wl[10] wl[11] wl[12] wl[13] wl[14] wl[15] bl[0] bl_n[0] bl[1] bl_n[1] bl[2] bl_n[2] bl[3] bl_n[3] bl[4] bl_n[4] bl[5] bl_n[5] bl[6] bl_n[6] bl[7] bl_n[7] bl[8] bl_n[8] bl[9] bl_n[9] bl[10] bl_n[10] bl[11] bl_n[11] bl[12] bl_n[12] bl[13] bl_n[13] bl[14] bl_n[14] bl[15] bl_n[15] bl[16] bl_n[16] bl[17] bl_n[17] bl[18] bl_n[18] bl[19] bl_n[19] bl[20] bl_n[20] bl[21] bl_n[21] bl[22] bl_n[22] bl[23] bl_n[23] bl[24] bl_n[24] bl[25] bl_n[25] bl[26] bl_n[26] bl[27] bl_n[27] bl[28] bl_n[28] bl[29] bl_n[29] bl[30] bl_n[30] bl[31] bl_n[31] SP6T1Array_16X32
Xinst1x0 vss vss vdd vdd wl[16] wl[17] wl[18] wl[19] wl[20] wl[21] wl[22] wl[23] wl[24] wl[25] wl[26] wl[27] wl[28] wl[29] wl[30] wl[31] bl[0] bl_n[0] bl[1] bl_n[1] bl[2] bl_n[2] bl[3] bl_n[3] bl[4] bl_n[4] bl[5] bl_n[5] bl[6] bl_n[6] bl[7] bl_n[7] bl[8] bl_n[8] bl[9] bl_n[9] bl[10] bl_n[10] bl[11] bl_n[11] bl[12] bl_n[12] bl[13] bl_n[13] bl[14] bl_n[14] bl[15] bl_n[15] bl[16] bl_n[16] bl[17] bl_n[17] bl[18] bl_n[18] bl[19] bl_n[19] bl[20] bl_n[20] bl[21] bl_n[21] bl[22] bl_n[22] bl[23] bl_n[23] bl[24] bl_n[24] bl[25] bl_n[25] bl[26] bl_n[26] bl[27] bl_n[27] bl[28] bl_n[28] bl[29] bl_n[29] bl[30] bl_n[30] bl[31] bl_n[31] SP6T1Array_16X32
Xbcrow vss vdd bl[0] bl_n[0] bl[1] bl_n[1] bl[2] bl_n[2] bl[3] bl_n[3] bl[4] bl_n[4] bl[5] bl_n[5] bl[6] bl_n[6] bl[7] bl_n[7] bl[8] bl_n[8] bl[9] bl_n[9] bl[10] bl_n[10] bl[11] bl_n[11] bl[12] bl_n[12] bl[13] bl_n[13] bl[14] bl_n[14] bl[15] bl_n[15] bl[16] bl_n[16] bl[17] bl_n[17] bl[18] bl_n[18] bl[19] bl_n[19] bl[20] bl_n[20] bl[21] bl_n[21] bl[22] bl_n[22] bl[23] bl_n[23] bl[24] bl_n[24] bl[25] bl_n[25] bl[26] bl_n[26] bl[27] bl_n[27] bl[28] bl_n[28] bl[29] bl_n[29] bl[30] bl_n[30] bl[31] bl_n[31] SP6T1BulkConnRow_32C
.ends SP6T1Array_32X32

.subckt SP6T1Array_64X32 vss vdd wl[0] wl[1] wl[2] wl[3] wl[4] wl[5] wl[6] wl[7] wl[8] wl[9] wl[10] wl[11] wl[12] wl[13] wl[14] wl[15] wl[16] wl[17] wl[18] wl[19] wl[20] wl[21] wl[22] wl[23] wl[24] wl[25] wl[26] wl[27] wl[28] wl[29] wl[30] wl[31] wl[32] wl[33] wl[34] wl[35] wl[36] wl[37] wl[38] wl[39] wl[40] wl[41] wl[42] wl[43] wl[44] wl[45] wl[46] wl[47] wl[48] wl[49] wl[50] wl[51] wl[52] wl[53] wl[54] wl[55] wl[56] wl[57] wl[58] wl[59] wl[60] wl[61] wl[62] wl[63] bl[0] bl_n[0] bl[1] bl_n[1] bl[2] bl_n[2] bl[3] bl_n[3] bl[4] bl_n[4] bl[5] bl_n[5] bl[6] bl_n[6] bl[7] bl_n[7] bl[8] bl_n[8] bl[9] bl_n[9] bl[10] bl_n[10] bl[11] bl_n[11] bl[12] bl_n[12] bl[13] bl_n[13] bl[14] bl_n[14] bl[15] bl_n[15] bl[16] bl_n[16] bl[17] bl_n[17] bl[18] bl_n[18] bl[19] bl_n[19] bl[20] bl_n[20] bl[21] bl_n[21] bl[22] bl_n[22] bl[23] bl_n[23] bl[24] bl_n[24] bl[25] bl_n[25] bl[26] bl_n[26] bl[27] bl_n[27] bl[28] bl_n[28] bl[29] bl_n[29] bl[30] bl_n[30] bl[31] bl_n[31]
Xinst0x0 vss vdd wl[0] wl[1] wl[2] wl[3] wl[4] wl[5] wl[6] wl[7] wl[8] wl[9] wl[10] wl[11] wl[12] wl[13] wl[14] wl[15] wl[16] wl[17] wl[18] wl[19] wl[20] wl[21] wl[22] wl[23] wl[24] wl[25] wl[26] wl[27] wl[28] wl[29] wl[30] wl[31] bl[0] bl_n[0] bl[1] bl_n[1] bl[2] bl_n[2] bl[3] bl_n[3] bl[4] bl_n[4] bl[5] bl_n[5] bl[6] bl_n[6] bl[7] bl_n[7] bl[8] bl_n[8] bl[9] bl_n[9] bl[10] bl_n[10] bl[11] bl_n[11] bl[12] bl_n[12] bl[13] bl_n[13] bl[14] bl_n[14] bl[15] bl_n[15] bl[16] bl_n[16] bl[17] bl_n[17] bl[18] bl_n[18] bl[19] bl_n[19] bl[20] bl_n[20] bl[21] bl_n[21] bl[22] bl_n[22] bl[23] bl_n[23] bl[24] bl_n[24] bl[25] bl_n[25] bl[26] bl_n[26] bl[27] bl_n[27] bl[28] bl_n[28] bl[29] bl_n[29] bl[30] bl_n[30] bl[31] bl_n[31] SP6T1Array_32X32
Xinst1x0 vss vdd wl[32] wl[33] wl[34] wl[35] wl[36] wl[37] wl[38] wl[39] wl[40] wl[41] wl[42] wl[43] wl[44] wl[45] wl[46] wl[47] wl[48] wl[49] wl[50] wl[51] wl[52] wl[53] wl[54] wl[55] wl[56] wl[57] wl[58] wl[59] wl[60] wl[61] wl[62] wl[63] bl[0] bl_n[0] bl[1] bl_n[1] bl[2] bl_n[2] bl[3] bl_n[3] bl[4] bl_n[4] bl[5] bl_n[5] bl[6] bl_n[6] bl[7] bl_n[7] bl[8] bl_n[8] bl[9] bl_n[9] bl[10] bl_n[10] bl[11] bl_n[11] bl[12] bl_n[12] bl[13] bl_n[13] bl[14] bl_n[14] bl[15] bl_n[15] bl[16] bl_n[16] bl[17] bl_n[17] bl[18] bl_n[18] bl[19] bl_n[19] bl[20] bl_n[20] bl[21] bl_n[21] bl[22] bl_n[22] bl[23] bl_n[23] bl[24] bl_n[24] bl[25] bl_n[25] bl[26] bl_n[26] bl[27] bl_n[27] bl[28] bl_n[28] bl[29] bl_n[29] bl[30] bl_n[30] bl[31] bl_n[31] SP6T1Array_32X32
Xbcrow vss vdd bl[0] bl_n[0] bl[1] bl_n[1] bl[2] bl_n[2] bl[3] bl_n[3] bl[4] bl_n[4] bl[5] bl_n[5] bl[6] bl_n[6] bl[7] bl_n[7] bl[8] bl_n[8] bl[9] bl_n[9] bl[10] bl_n[10] bl[11] bl_n[11] bl[12] bl_n[12] bl[13] bl_n[13] bl[14] bl_n[14] bl[15] bl_n[15] bl[16] bl_n[16] bl[17] bl_n[17] bl[18] bl_n[18] bl[19] bl_n[19] bl[20] bl_n[20] bl[21] bl_n[21] bl[22] bl_n[22] bl[23] bl_n[23] bl[24] bl_n[24] bl[25] bl_n[25] bl[26] bl_n[26] bl[27] bl_n[27] bl[28] bl_n[28] bl[29] bl_n[29] bl[30] bl_n[30] bl[31] bl_n[31] SP6T1BulkConnRow_32C
.ends SP6T1Array_64X32

.subckt SP6T1Array_128X32BC vss vdd wl[0] wl[1] wl[2] wl[3] wl[4] wl[5] wl[6] wl[7] wl[8] wl[9] wl[10] wl[11] wl[12] wl[13] wl[14] wl[15] wl[16] wl[17] wl[18] wl[19] wl[20] wl[21] wl[22] wl[23] wl[24] wl[25] wl[26] wl[27] wl[28] wl[29] wl[30] wl[31] wl[32] wl[33] wl[34] wl[35] wl[36] wl[37] wl[38] wl[39] wl[40] wl[41] wl[42] wl[43] wl[44] wl[45] wl[46] wl[47] wl[48] wl[49] wl[50] wl[51] wl[52] wl[53] wl[54] wl[55] wl[56] wl[57] wl[58] wl[59] wl[60] wl[61] wl[62] wl[63] wl[64] wl[65] wl[66] wl[67] wl[68] wl[69] wl[70] wl[71] wl[72] wl[73] wl[74] wl[75] wl[76] wl[77] wl[78] wl[79] wl[80] wl[81] wl[82] wl[83] wl[84] wl[85] wl[86] wl[87] wl[88] wl[89] wl[90] wl[91] wl[92] wl[93] wl[94] wl[95] wl[96] wl[97] wl[98] wl[99] wl[100] wl[101] wl[102] wl[103] wl[104] wl[105] wl[106] wl[107] wl[108] wl[109] wl[110] wl[111] wl[112] wl[113] wl[114] wl[115] wl[116] wl[117] wl[118] wl[119] wl[120] wl[121] wl[122] wl[123] wl[124] wl[125] wl[126] wl[127] bl[0] bl_n[0] bl[1] bl_n[1] bl[2] bl_n[2] bl[3] bl_n[3] bl[4] bl_n[4] bl[5] bl_n[5] bl[6] bl_n[6] bl[7] bl_n[7] bl[8] bl_n[8] bl[9] bl_n[9] bl[10] bl_n[10] bl[11] bl_n[11] bl[12] bl_n[12] bl[13] bl_n[13] bl[14] bl_n[14] bl[15] bl_n[15] bl[16] bl_n[16] bl[17] bl_n[17] bl[18] bl_n[18] bl[19] bl_n[19] bl[20] bl_n[20] bl[21] bl_n[21] bl[22] bl_n[22] bl[23] bl_n[23] bl[24] bl_n[24] bl[25] bl_n[25] bl[26] bl_n[26] bl[27] bl_n[27] bl[28] bl_n[28] bl[29] bl_n[29] bl[30] bl_n[30] bl[31] bl_n[31]
Xinst0x0 vss vdd wl[0] wl[1] wl[2] wl[3] wl[4] wl[5] wl[6] wl[7] wl[8] wl[9] wl[10] wl[11] wl[12] wl[13] wl[14] wl[15] wl[16] wl[17] wl[18] wl[19] wl[20] wl[21] wl[22] wl[23] wl[24] wl[25] wl[26] wl[27] wl[28] wl[29] wl[30] wl[31] wl[32] wl[33] wl[34] wl[35] wl[36] wl[37] wl[38] wl[39] wl[40] wl[41] wl[42] wl[43] wl[44] wl[45] wl[46] wl[47] wl[48] wl[49] wl[50] wl[51] wl[52] wl[53] wl[54] wl[55] wl[56] wl[57] wl[58] wl[59] wl[60] wl[61] wl[62] wl[63] bl[0] bl_n[0] bl[1] bl_n[1] bl[2] bl_n[2] bl[3] bl_n[3] bl[4] bl_n[4] bl[5] bl_n[5] bl[6] bl_n[6] bl[7] bl_n[7] bl[8] bl_n[8] bl[9] bl_n[9] bl[10] bl_n[10] bl[11] bl_n[11] bl[12] bl_n[12] bl[13] bl_n[13] bl[14] bl_n[14] bl[15] bl_n[15] bl[16] bl_n[16] bl[17] bl_n[17] bl[18] bl_n[18] bl[19] bl_n[19] bl[20] bl_n[20] bl[21] bl_n[21] bl[22] bl_n[22] bl[23] bl_n[23] bl[24] bl_n[24] bl[25] bl_n[25] bl[26] bl_n[26] bl[27] bl_n[27] bl[28] bl_n[28] bl[29] bl_n[29] bl[30] bl_n[30] bl[31] bl_n[31] SP6T1Array_64X32
Xinst1x0 vss vdd wl[64] wl[65] wl[66] wl[67] wl[68] wl[69] wl[70] wl[71] wl[72] wl[73] wl[74] wl[75] wl[76] wl[77] wl[78] wl[79] wl[80] wl[81] wl[82] wl[83] wl[84] wl[85] wl[86] wl[87] wl[88] wl[89] wl[90] wl[91] wl[92] wl[93] wl[94] wl[95] wl[96] wl[97] wl[98] wl[99] wl[100] wl[101] wl[102] wl[103] wl[104] wl[105] wl[106] wl[107] wl[108] wl[109] wl[110] wl[111] wl[112] wl[113] wl[114] wl[115] wl[116] wl[117] wl[118] wl[119] wl[120] wl[121] wl[122] wl[123] wl[124] wl[125] wl[126] wl[127] bl[0] bl_n[0] bl[1] bl_n[1] bl[2] bl_n[2] bl[3] bl_n[3] bl[4] bl_n[4] bl[5] bl_n[5] bl[6] bl_n[6] bl[7] bl_n[7] bl[8] bl_n[8] bl[9] bl_n[9] bl[10] bl_n[10] bl[11] bl_n[11] bl[12] bl_n[12] bl[13] bl_n[13] bl[14] bl_n[14] bl[15] bl_n[15] bl[16] bl_n[16] bl[17] bl_n[17] bl[18] bl_n[18] bl[19] bl_n[19] bl[20] bl_n[20] bl[21] bl_n[21] bl[22] bl_n[22] bl[23] bl_n[23] bl[24] bl_n[24] bl[25] bl_n[25] bl[26] bl_n[26] bl[27] bl_n[27] bl[28] bl_n[28] bl[29] bl_n[29] bl[30] bl_n[30] bl[31] bl_n[31] SP6T1Array_64X32
Xbcrow vss vdd bl[0] bl_n[0] bl[1] bl_n[1] bl[2] bl_n[2] bl[3] bl_n[3] bl[4] bl_n[4] bl[5] bl_n[5] bl[6] bl_n[6] bl[7] bl_n[7] bl[8] bl_n[8] bl[9] bl_n[9] bl[10] bl_n[10] bl[11] bl_n[11] bl[12] bl_n[12] bl[13] bl_n[13] bl[14] bl_n[14] bl[15] bl_n[15] bl[16] bl_n[16] bl[17] bl_n[17] bl[18] bl_n[18] bl[19] bl_n[19] bl[20] bl_n[20] bl[21] bl_n[21] bl[22] bl_n[22] bl[23] bl_n[23] bl[24] bl_n[24] bl[25] bl_n[25] bl[26] bl_n[26] bl[27] bl_n[27] bl[28] bl_n[28] bl[29] bl_n[29] bl[30] bl_n[30] bl[31] bl_n[31] SP6T1BulkConnRow_32C
Xbottombcrow vss vdd bl[0] bl_n[0] bl[1] bl_n[1] bl[2] bl_n[2] bl[3] bl_n[3] bl[4] bl_n[4] bl[5] bl_n[5] bl[6] bl_n[6] bl[7] bl_n[7] bl[8] bl_n[8] bl[9] bl_n[9] bl[10] bl_n[10] bl[11] bl_n[11] bl[12] bl_n[12] bl[13] bl_n[13] bl[14] bl_n[14] bl[15] bl_n[15] bl[16] bl_n[16] bl[17] bl_n[17] bl[18] bl_n[18] bl[19] bl_n[19] bl[20] bl_n[20] bl[21] bl_n[21] bl[22] bl_n[22] bl[23] bl_n[23] bl[24] bl_n[24] bl[25] bl_n[25] bl[26] bl_n[26] bl[27] bl_n[27] bl[28] bl_n[28] bl[29] bl_n[29] bl[30] bl_n[30] bl[31] bl_n[31] SP6T1BulkConnRow_32C
Xtopbcrow vss vdd bl[0] bl_n[0] bl[1] bl_n[1] bl[2] bl_n[2] bl[3] bl_n[3] bl[4] bl_n[4] bl[5] bl_n[5] bl[6] bl_n[6] bl[7] bl_n[7] bl[8] bl_n[8] bl[9] bl_n[9] bl[10] bl_n[10] bl[11] bl_n[11] bl[12] bl_n[12] bl[13] bl_n[13] bl[14] bl_n[14] bl[15] bl_n[15] bl[16] bl_n[16] bl[17] bl_n[17] bl[18] bl_n[18] bl[19] bl_n[19] bl[20] bl_n[20] bl[21] bl_n[21] bl[22] bl_n[22] bl[23] bl_n[23] bl[24] bl_n[24] bl[25] bl_n[25] bl[26] bl_n[26] bl[27] bl_n[27] bl[28] bl_n[28] bl[29] bl_n[29] bl[30] bl_n[30] bl[31] bl_n[31] SP6T1BulkConnRow_32C
.ends SP6T1Array_128X32BC

.subckt SP6T1Precharge_26L100W vdd nwell bl bl_n precharge_n
Xpc1 vdd precharge_n bl nwell sg13_lv_pmos l=1.3e-07 w=5e-07
Xpc2 bl precharge_n bl_n nwell sg13_lv_pmos l=1.3e-07 w=5e-07
Xpc3 bl_n precharge_n vdd nwell sg13_lv_pmos l=1.3e-07 w=5e-07
.ends SP6T1Precharge_26L100W

.subckt SP6T1ColMux_4MN26L580W1R bl[0] bl_n[0] mux[0] bl[1] bl_n[1] mux[1] bl[2] bl_n[2] mux[2] bl[3] bl_n[3] mux[3] vss muxbl muxbl_n
Xpgbl0 muxbl mux[0] bl[0] vss sg13_lv_nmos l=1.3e-07 w=2.9e-06
Xpgbln0 bl_n[0] mux[0] muxbl_n vss sg13_lv_nmos l=1.3e-07 w=2.9e-06
Xpgbl1 bl[1] mux[1] muxbl vss sg13_lv_nmos l=1.3e-07 w=2.9e-06
Xpgbln1 muxbl_n mux[1] bl_n[1] vss sg13_lv_nmos l=1.3e-07 w=2.9e-06
Xpgbl2 muxbl mux[2] bl[2] vss sg13_lv_nmos l=1.3e-07 w=2.9e-06
Xpgbln2 bl_n[2] mux[2] muxbl_n vss sg13_lv_nmos l=1.3e-07 w=2.9e-06
Xpgbl3 bl[3] mux[3] muxbl vss sg13_lv_nmos l=1.3e-07 w=2.9e-06
Xpgbln3 muxbl_n mux[3] bl_n[3] vss sg13_lv_nmos l=1.3e-07 w=2.9e-06
.ends SP6T1ColMux_4MN26L580W1R

.subckt nsnrlatch_x1 vdd vss nset nrst q nq
Xnset_nmos q nset _net0 vss sg13_lv_nmos l=1.3e-07 w=1.31e-06
Xnset_pmos vdd nset q vdd sg13_lv_pmos l=1.3e-07 w=1.3e-06
Xnq_nmos _net0 nq vss vss sg13_lv_nmos l=1.3e-07 w=1.31e-06
Xnq_pmos q nq vdd vdd sg13_lv_pmos l=1.3e-07 w=1.3e-06
Xq_nmos vss q _net1 vss sg13_lv_nmos l=1.3e-07 w=1.31e-06
Xq_pmos vdd q nq vdd sg13_lv_pmos l=1.3e-07 w=1.3e-06
Xnrst_nmos _net1 nrst nq vss sg13_lv_nmos l=1.3e-07 w=1.31e-06
Xnrst_pmos nq nrst vdd vdd sg13_lv_pmos l=1.3e-07 w=1.3e-06
.ends nsnrlatch_x1

.subckt dff_x1 vdd vss i clk q
Xclk_nmos _clk_n clk vss vss sg13_lv_nmos l=1.3e-07 w=7.8e-07
Xclk_pmos _clk_n clk vdd vdd sg13_lv_pmos l=1.3e-07 w=7.8e-07
Xclk_n_nmos0 vss _clk_n _clk_buf vss sg13_lv_nmos l=1.3e-07 w=7.8e-07
Xclk_n_pmos0 vdd _clk_n _clk_buf vdd sg13_lv_pmos l=1.3e-07 w=7.8e-07
Xi_nmos _u i vss vss sg13_lv_nmos l=1.3e-07 w=7.8e-07
Xi_pmos _u i vdd vdd sg13_lv_pmos l=1.3e-07 w=7.8e-07
Xu_nmos vss _u _net0 vss sg13_lv_nmos l=1.3e-07 w=7.8e-07
Xu_pmos vdd _u _net1 vdd sg13_lv_pmos l=1.3e-07 w=7.8e-07
Xclk_n_nmos1 _net0 _clk_n _dff_m vss sg13_lv_nmos l=1.3e-07 w=7.8e-07
Xclk_buf_pmos0 _net1 _clk_buf _dff_m vdd sg13_lv_pmos l=1.3e-07 w=7.8e-07
Xclk_buf_nmos0 _dff_m _clk_buf _net2 vss sg13_lv_nmos l=1.3e-07 w=7.8e-07
Xclk_n_pmos1 _dff_m _clk_n _net3 vdd sg13_lv_pmos l=1.3e-07 w=7.8e-07
Xy_nmos _net2 _y vss vss sg13_lv_nmos l=1.3e-07 w=7.8e-07
Xy_pmos _net3 _y vdd vdd sg13_lv_pmos l=1.3e-07 w=7.8e-07
Xdff_m_nmos vss _dff_m _y vss sg13_lv_nmos l=1.3e-07 w=7.8e-07
Xdff_m_pmos vdd _dff_m _y vdd sg13_lv_pmos l=1.3e-07 w=7.8e-07
Xclk_buf_nmos1 _y _clk_buf _dff_s vss sg13_lv_nmos l=1.3e-07 w=7.8e-07
Xclk_n_pmos2 _y _clk_n _dff_s vdd sg13_lv_pmos l=1.3e-07 w=7.8e-07
Xclk_n_nmos2 _dff_s _clk_n _net4 vss sg13_lv_nmos l=1.3e-07 w=7.8e-07
Xclk_buf_pmos1 _dff_s _clk_buf _net5 vdd sg13_lv_pmos l=1.3e-07 w=7.8e-07
Xq_nmos _net4 q vss vss sg13_lv_nmos l=1.3e-07 w=7.8e-07
Xq_pmos _net5 q vdd vdd sg13_lv_pmos l=1.3e-07 w=7.8e-07
Xdff_s_nmos vss _dff_s q vss sg13_lv_nmos l=1.3e-07 w=8.3e-07
Xdff_s_pmos vdd _dff_s q vdd sg13_lv_pmos l=1.3e-07 w=8.2e-07
.ends dff_x1

.subckt inv_x0 vdd vss i nq
Xnmos vss i nq vss sg13_lv_nmos l=1.3e-07 w=7.8e-07
Xpmos vdd i nq vdd sg13_lv_pmos l=1.3e-07 w=7.8e-07
.ends inv_x0

.subckt nor2_x0 vdd vss nq i0 i1
Xi0_nmos vss i0 nq vss sg13_lv_nmos l=1.3e-07 w=7.8e-07
Xi0_pmos vdd i0 _net0 vdd sg13_lv_pmos l=1.3e-07 w=7.8e-07
Xi1_nmos nq i1 vss vss sg13_lv_nmos l=1.3e-07 w=7.8e-07
Xi1_pmos _net0 i1 nq vdd sg13_lv_pmos l=1.3e-07 w=7.8e-07
.ends nor2_x0

.subckt SP6T1ReadWrite_CM4MN26L580W1R_WD26L380W vss vdd d q bl bl_n clk we_n
Xsenseamp vdd vss bl_n bl q noconn nsnrlatch_x1
Xd_ff vdd vss d clk d_l dff_x1
Xd_inv vdd vss d_l d_n inv_x0
Xnora vdd vss bl_pd_g d_l we_n nor2_x0
Xnorb vdd vss bln_pd_g d_n we_n nor2_x0
Xbl_pd bl bl_pd_g vss vss sg13_lv_nmos l=1.3e-07 w=1.9e-06
Xbln_pd vss bln_pd_g bl_n vss sg13_lv_nmos l=1.3e-07 w=1.9e-06
.ends SP6T1ReadWrite_CM4MN26L580W1R_WD26L380W

.subckt buf_x2 vdd vss i q
Xstage0_nmos _i_n i vss vss sg13_lv_nmos l=1.3e-07 w=7.8e-07
Xstage0_pmos _i_n i vdd vdd sg13_lv_pmos l=1.3e-07 w=7.8e-07
Xnmos[0] vss _i_n q vss sg13_lv_nmos l=1.3e-07 w=1.07e-06
Xpmos[0] vdd _i_n q vdd sg13_lv_pmos l=1.3e-07 w=1.06e-06
Xnmos[1] q _i_n vss vss sg13_lv_nmos l=1.3e-07 w=1.07e-06
Xpmos[1] q _i_n vdd vdd sg13_lv_pmos l=1.3e-07 w=1.06e-06
.ends buf_x2

.subckt nand2_x0 vdd vss nq i0 i1
Xi0_nmos vss i0 _net0 vss sg13_lv_nmos l=1.3e-07 w=7.8e-07
Xi0_pmos vdd i0 nq vdd sg13_lv_pmos l=1.3e-07 w=7.8e-07
Xi1_nmos _net0 i1 nq vss sg13_lv_nmos l=1.3e-07 w=7.8e-07
Xi1_pmos nq i1 vdd vdd sg13_lv_pmos l=1.3e-07 w=7.8e-07
.ends nand2_x0

.subckt SP6T1ClockWE vss vdd clkup clkdown we we_en we_n
Xclkbuf vdd vss clkup clkdown buf_x2
Xweff vdd vss we clkdown we_l dff_x1
Xwenand vdd vss we_n we_l we_en nand2_x0
.ends SP6T1ClockWE

.subckt SP6T1ColPeriph8B_PC26L100W_CM4MN26L580W1R vss vdd nwell clk precharge_n we we_en q[0] d[0] bl[0] bl_n[0] bl[1] bl_n[1] bl[2] bl_n[2] bl[3] bl_n[3] q[1] d[1] bl[4] bl_n[4] bl[5] bl_n[5] bl[6] bl_n[6] bl[7] bl_n[7] q[2] d[2] bl[8] bl_n[8] bl[9] bl_n[9] bl[10] bl_n[10] bl[11] bl_n[11] q[3] d[3] bl[12] bl_n[12] bl[13] bl_n[13] bl[14] bl_n[14] bl[15] bl_n[15] q[4] d[4] bl[16] bl_n[16] bl[17] bl_n[17] bl[18] bl_n[18] bl[19] bl_n[19] q[5] d[5] bl[20] bl_n[20] bl[21] bl_n[21] bl[22] bl_n[22] bl[23] bl_n[23] q[6] d[6] bl[24] bl_n[24] bl[25] bl_n[25] bl[26] bl_n[26] bl[27] bl_n[27] q[7] d[7] bl[28] bl_n[28] bl[29] bl_n[29] bl[30] bl_n[30] bl[31] bl_n[31] mux[0] mux[1] mux[2] mux[3]
Xprecharge[0] vdd nwell bl[0] bl_n[0] precharge_n SP6T1Precharge_26L100W
Xprecharge[1] vdd nwell bl[1] bl_n[1] precharge_n SP6T1Precharge_26L100W
Xprecharge[2] vdd nwell bl[2] bl_n[2] precharge_n SP6T1Precharge_26L100W
Xprecharge[3] vdd nwell bl[3] bl_n[3] precharge_n SP6T1Precharge_26L100W
Xprecharge[4] vdd nwell bl[4] bl_n[4] precharge_n SP6T1Precharge_26L100W
Xprecharge[5] vdd nwell bl[5] bl_n[5] precharge_n SP6T1Precharge_26L100W
Xprecharge[6] vdd nwell bl[6] bl_n[6] precharge_n SP6T1Precharge_26L100W
Xprecharge[7] vdd nwell bl[7] bl_n[7] precharge_n SP6T1Precharge_26L100W
Xprecharge[8] vdd nwell bl[8] bl_n[8] precharge_n SP6T1Precharge_26L100W
Xprecharge[9] vdd nwell bl[9] bl_n[9] precharge_n SP6T1Precharge_26L100W
Xprecharge[10] vdd nwell bl[10] bl_n[10] precharge_n SP6T1Precharge_26L100W
Xprecharge[11] vdd nwell bl[11] bl_n[11] precharge_n SP6T1Precharge_26L100W
Xprecharge[12] vdd nwell bl[12] bl_n[12] precharge_n SP6T1Precharge_26L100W
Xprecharge[13] vdd nwell bl[13] bl_n[13] precharge_n SP6T1Precharge_26L100W
Xprecharge[14] vdd nwell bl[14] bl_n[14] precharge_n SP6T1Precharge_26L100W
Xprecharge[15] vdd nwell bl[15] bl_n[15] precharge_n SP6T1Precharge_26L100W
Xprecharge[16] vdd nwell bl[16] bl_n[16] precharge_n SP6T1Precharge_26L100W
Xprecharge[17] vdd nwell bl[17] bl_n[17] precharge_n SP6T1Precharge_26L100W
Xprecharge[18] vdd nwell bl[18] bl_n[18] precharge_n SP6T1Precharge_26L100W
Xprecharge[19] vdd nwell bl[19] bl_n[19] precharge_n SP6T1Precharge_26L100W
Xprecharge[20] vdd nwell bl[20] bl_n[20] precharge_n SP6T1Precharge_26L100W
Xprecharge[21] vdd nwell bl[21] bl_n[21] precharge_n SP6T1Precharge_26L100W
Xprecharge[22] vdd nwell bl[22] bl_n[22] precharge_n SP6T1Precharge_26L100W
Xprecharge[23] vdd nwell bl[23] bl_n[23] precharge_n SP6T1Precharge_26L100W
Xprecharge[24] vdd nwell bl[24] bl_n[24] precharge_n SP6T1Precharge_26L100W
Xprecharge[25] vdd nwell bl[25] bl_n[25] precharge_n SP6T1Precharge_26L100W
Xprecharge[26] vdd nwell bl[26] bl_n[26] precharge_n SP6T1Precharge_26L100W
Xprecharge[27] vdd nwell bl[27] bl_n[27] precharge_n SP6T1Precharge_26L100W
Xprecharge[28] vdd nwell bl[28] bl_n[28] precharge_n SP6T1Precharge_26L100W
Xprecharge[29] vdd nwell bl[29] bl_n[29] precharge_n SP6T1Precharge_26L100W
Xprecharge[30] vdd nwell bl[30] bl_n[30] precharge_n SP6T1Precharge_26L100W
Xprecharge[31] vdd nwell bl[31] bl_n[31] precharge_n SP6T1Precharge_26L100W
Xcolmux[0] bl[0] bl_n[0] mux[0] bl[1] bl_n[1] mux[1] bl[2] bl_n[2] mux[2] bl[3] bl_n[3] mux[3] vss muxbl[0] muxbl_n[0] SP6T1ColMux_4MN26L580W1R
Xcolmux[1] bl[4] bl_n[4] mux[0] bl[5] bl_n[5] mux[1] bl[6] bl_n[6] mux[2] bl[7] bl_n[7] mux[3] vss muxbl[1] muxbl_n[1] SP6T1ColMux_4MN26L580W1R
Xcolmux[2] bl[8] bl_n[8] mux[0] bl[9] bl_n[9] mux[1] bl[10] bl_n[10] mux[2] bl[11] bl_n[11] mux[3] vss muxbl[2] muxbl_n[2] SP6T1ColMux_4MN26L580W1R
Xcolmux[3] bl[12] bl_n[12] mux[0] bl[13] bl_n[13] mux[1] bl[14] bl_n[14] mux[2] bl[15] bl_n[15] mux[3] vss muxbl[3] muxbl_n[3] SP6T1ColMux_4MN26L580W1R
Xcolmux[4] bl[16] bl_n[16] mux[0] bl[17] bl_n[17] mux[1] bl[18] bl_n[18] mux[2] bl[19] bl_n[19] mux[3] vss muxbl[4] muxbl_n[4] SP6T1ColMux_4MN26L580W1R
Xcolmux[5] bl[20] bl_n[20] mux[0] bl[21] bl_n[21] mux[1] bl[22] bl_n[22] mux[2] bl[23] bl_n[23] mux[3] vss muxbl[5] muxbl_n[5] SP6T1ColMux_4MN26L580W1R
Xcolmux[6] bl[24] bl_n[24] mux[0] bl[25] bl_n[25] mux[1] bl[26] bl_n[26] mux[2] bl[27] bl_n[27] mux[3] vss muxbl[6] muxbl_n[6] SP6T1ColMux_4MN26L580W1R
Xcolmux[7] bl[28] bl_n[28] mux[0] bl[29] bl_n[29] mux[1] bl[30] bl_n[30] mux[2] bl[31] bl_n[31] mux[3] vss muxbl[7] muxbl_n[7] SP6T1ColMux_4MN26L580W1R
Xrw[0] vss vdd d[0] q[0] muxbl[0] muxbl_n[0] intclk we_n SP6T1ReadWrite_CM4MN26L580W1R_WD26L380W
Xrw[1] vss vdd d[1] q[1] muxbl[1] muxbl_n[1] intclk we_n SP6T1ReadWrite_CM4MN26L580W1R_WD26L380W
Xrw[2] vss vdd d[2] q[2] muxbl[2] muxbl_n[2] intclk we_n SP6T1ReadWrite_CM4MN26L580W1R_WD26L380W
Xrw[3] vss vdd d[3] q[3] muxbl[3] muxbl_n[3] intclk we_n SP6T1ReadWrite_CM4MN26L580W1R_WD26L380W
Xrw[4] vss vdd d[4] q[4] muxbl[4] muxbl_n[4] intclk we_n SP6T1ReadWrite_CM4MN26L580W1R_WD26L380W
Xrw[5] vss vdd d[5] q[5] muxbl[5] muxbl_n[5] intclk we_n SP6T1ReadWrite_CM4MN26L580W1R_WD26L380W
Xrw[6] vss vdd d[6] q[6] muxbl[6] muxbl_n[6] intclk we_n SP6T1ReadWrite_CM4MN26L580W1R_WD26L380W
Xrw[7] vss vdd d[7] q[7] muxbl[7] muxbl_n[7] intclk we_n SP6T1ReadWrite_CM4MN26L580W1R_WD26L380W
Xclkwe vss vdd clk intclk we we_en we_n SP6T1ClockWE
.ends SP6T1ColPeriph8B_PC26L100W_CM4MN26L580W1R

.subckt SP6T1Column_128R_CP8B_CM4MN26L580W1R_PC26L100W vss vdd wl[0] wl[1] wl[2] wl[3] wl[4] wl[5] wl[6] wl[7] wl[8] wl[9] wl[10] wl[11] wl[12] wl[13] wl[14] wl[15] wl[16] wl[17] wl[18] wl[19] wl[20] wl[21] wl[22] wl[23] wl[24] wl[25] wl[26] wl[27] wl[28] wl[29] wl[30] wl[31] wl[32] wl[33] wl[34] wl[35] wl[36] wl[37] wl[38] wl[39] wl[40] wl[41] wl[42] wl[43] wl[44] wl[45] wl[46] wl[47] wl[48] wl[49] wl[50] wl[51] wl[52] wl[53] wl[54] wl[55] wl[56] wl[57] wl[58] wl[59] wl[60] wl[61] wl[62] wl[63] wl[64] wl[65] wl[66] wl[67] wl[68] wl[69] wl[70] wl[71] wl[72] wl[73] wl[74] wl[75] wl[76] wl[77] wl[78] wl[79] wl[80] wl[81] wl[82] wl[83] wl[84] wl[85] wl[86] wl[87] wl[88] wl[89] wl[90] wl[91] wl[92] wl[93] wl[94] wl[95] wl[96] wl[97] wl[98] wl[99] wl[100] wl[101] wl[102] wl[103] wl[104] wl[105] wl[106] wl[107] wl[108] wl[109] wl[110] wl[111] wl[112] wl[113] wl[114] wl[115] wl[116] wl[117] wl[118] wl[119] wl[120] wl[121] wl[122] wl[123] wl[124] wl[125] wl[126] wl[127] q[0] d[0] q[1] d[1] q[2] d[2] q[3] d[3] q[4] d[4] q[5] d[5] q[6] d[6] q[7] d[7] we clk we_en precharge_n mux[0] mux[1] mux[2] mux[3]
Xarray vss vdd wl[0] wl[1] wl[2] wl[3] wl[4] wl[5] wl[6] wl[7] wl[8] wl[9] wl[10] wl[11] wl[12] wl[13] wl[14] wl[15] wl[16] wl[17] wl[18] wl[19] wl[20] wl[21] wl[22] wl[23] wl[24] wl[25] wl[26] wl[27] wl[28] wl[29] wl[30] wl[31] wl[32] wl[33] wl[34] wl[35] wl[36] wl[37] wl[38] wl[39] wl[40] wl[41] wl[42] wl[43] wl[44] wl[45] wl[46] wl[47] wl[48] wl[49] wl[50] wl[51] wl[52] wl[53] wl[54] wl[55] wl[56] wl[57] wl[58] wl[59] wl[60] wl[61] wl[62] wl[63] wl[64] wl[65] wl[66] wl[67] wl[68] wl[69] wl[70] wl[71] wl[72] wl[73] wl[74] wl[75] wl[76] wl[77] wl[78] wl[79] wl[80] wl[81] wl[82] wl[83] wl[84] wl[85] wl[86] wl[87] wl[88] wl[89] wl[90] wl[91] wl[92] wl[93] wl[94] wl[95] wl[96] wl[97] wl[98] wl[99] wl[100] wl[101] wl[102] wl[103] wl[104] wl[105] wl[106] wl[107] wl[108] wl[109] wl[110] wl[111] wl[112] wl[113] wl[114] wl[115] wl[116] wl[117] wl[118] wl[119] wl[120] wl[121] wl[122] wl[123] wl[124] wl[125] wl[126] wl[127] bl[0] bl_n[0] bl[1] bl_n[1] bl[2] bl_n[2] bl[3] bl_n[3] bl[4] bl_n[4] bl[5] bl_n[5] bl[6] bl_n[6] bl[7] bl_n[7] bl[8] bl_n[8] bl[9] bl_n[9] bl[10] bl_n[10] bl[11] bl_n[11] bl[12] bl_n[12] bl[13] bl_n[13] bl[14] bl_n[14] bl[15] bl_n[15] bl[16] bl_n[16] bl[17] bl_n[17] bl[18] bl_n[18] bl[19] bl_n[19] bl[20] bl_n[20] bl[21] bl_n[21] bl[22] bl_n[22] bl[23] bl_n[23] bl[24] bl_n[24] bl[25] bl_n[25] bl[26] bl_n[26] bl[27] bl_n[27] bl[28] bl_n[28] bl[29] bl_n[29] bl[30] bl_n[30] bl[31] bl_n[31] SP6T1Array_128X32BC
Xperiph vss vdd vdd clk precharge_n we we_en q[0] d[0] bl[0] bl_n[0] bl[1] bl_n[1] bl[2] bl_n[2] bl[3] bl_n[3] q[1] d[1] bl[4] bl_n[4] bl[5] bl_n[5] bl[6] bl_n[6] bl[7] bl_n[7] q[2] d[2] bl[8] bl_n[8] bl[9] bl_n[9] bl[10] bl_n[10] bl[11] bl_n[11] q[3] d[3] bl[12] bl_n[12] bl[13] bl_n[13] bl[14] bl_n[14] bl[15] bl_n[15] q[4] d[4] bl[16] bl_n[16] bl[17] bl_n[17] bl[18] bl_n[18] bl[19] bl_n[19] q[5] d[5] bl[20] bl_n[20] bl[21] bl_n[21] bl[22] bl_n[22] bl[23] bl_n[23] q[6] d[6] bl[24] bl_n[24] bl[25] bl_n[25] bl[26] bl_n[26] bl[27] bl_n[27] q[7] d[7] bl[28] bl_n[28] bl[29] bl_n[29] bl[30] bl_n[30] bl[31] bl_n[31] mux[0] mux[1] mux[2] mux[3] SP6T1ColPeriph8B_PC26L100W_CM4MN26L580W1R
.ends SP6T1Column_128R_CP8B_CM4MN26L580W1R_PC26L100W

.subckt SP6T1ColumnBlock_COL128R_CP8B_CM4MN26L580W1R_PC26L100W_4WE vss vdd clk precharge_n we_en wl[0] wl[1] wl[2] wl[3] wl[4] wl[5] wl[6] wl[7] wl[8] wl[9] wl[10] wl[11] wl[12] wl[13] wl[14] wl[15] wl[16] wl[17] wl[18] wl[19] wl[20] wl[21] wl[22] wl[23] wl[24] wl[25] wl[26] wl[27] wl[28] wl[29] wl[30] wl[31] wl[32] wl[33] wl[34] wl[35] wl[36] wl[37] wl[38] wl[39] wl[40] wl[41] wl[42] wl[43] wl[44] wl[45] wl[46] wl[47] wl[48] wl[49] wl[50] wl[51] wl[52] wl[53] wl[54] wl[55] wl[56] wl[57] wl[58] wl[59] wl[60] wl[61] wl[62] wl[63] wl[64] wl[65] wl[66] wl[67] wl[68] wl[69] wl[70] wl[71] wl[72] wl[73] wl[74] wl[75] wl[76] wl[77] wl[78] wl[79] wl[80] wl[81] wl[82] wl[83] wl[84] wl[85] wl[86] wl[87] wl[88] wl[89] wl[90] wl[91] wl[92] wl[93] wl[94] wl[95] wl[96] wl[97] wl[98] wl[99] wl[100] wl[101] wl[102] wl[103] wl[104] wl[105] wl[106] wl[107] wl[108] wl[109] wl[110] wl[111] wl[112] wl[113] wl[114] wl[115] wl[116] wl[117] wl[118] wl[119] wl[120] wl[121] wl[122] wl[123] wl[124] wl[125] wl[126] wl[127] mux[0] mux[1] mux[2] mux[3] we[0] q[0] d[0] q[1] d[1] q[2] d[2] q[3] d[3] q[4] d[4] q[5] d[5] q[6] d[6] q[7] d[7] we[1] q[8] d[8] q[9] d[9] q[10] d[10] q[11] d[11] q[12] d[12] q[13] d[13] q[14] d[14] q[15] d[15] we[2] q[16] d[16] q[17] d[17] q[18] d[18] q[19] d[19] q[20] d[20] q[21] d[21] q[22] d[22] q[23] d[23] we[3] q[24] d[24] q[25] d[25] q[26] d[26] q[27] d[27] q[28] d[28] q[29] d[29] q[30] d[30] q[31] d[31]
Xcolumn[0] vss vdd wl[0] wl[1] wl[2] wl[3] wl[4] wl[5] wl[6] wl[7] wl[8] wl[9] wl[10] wl[11] wl[12] wl[13] wl[14] wl[15] wl[16] wl[17] wl[18] wl[19] wl[20] wl[21] wl[22] wl[23] wl[24] wl[25] wl[26] wl[27] wl[28] wl[29] wl[30] wl[31] wl[32] wl[33] wl[34] wl[35] wl[36] wl[37] wl[38] wl[39] wl[40] wl[41] wl[42] wl[43] wl[44] wl[45] wl[46] wl[47] wl[48] wl[49] wl[50] wl[51] wl[52] wl[53] wl[54] wl[55] wl[56] wl[57] wl[58] wl[59] wl[60] wl[61] wl[62] wl[63] wl[64] wl[65] wl[66] wl[67] wl[68] wl[69] wl[70] wl[71] wl[72] wl[73] wl[74] wl[75] wl[76] wl[77] wl[78] wl[79] wl[80] wl[81] wl[82] wl[83] wl[84] wl[85] wl[86] wl[87] wl[88] wl[89] wl[90] wl[91] wl[92] wl[93] wl[94] wl[95] wl[96] wl[97] wl[98] wl[99] wl[100] wl[101] wl[102] wl[103] wl[104] wl[105] wl[106] wl[107] wl[108] wl[109] wl[110] wl[111] wl[112] wl[113] wl[114] wl[115] wl[116] wl[117] wl[118] wl[119] wl[120] wl[121] wl[122] wl[123] wl[124] wl[125] wl[126] wl[127] q[0] d[0] q[1] d[1] q[2] d[2] q[3] d[3] q[4] d[4] q[5] d[5] q[6] d[6] q[7] d[7] we[0] clk we_en precharge_n mux[0] mux[1] mux[2] mux[3] SP6T1Column_128R_CP8B_CM4MN26L580W1R_PC26L100W
Xcolumn[1] vss vdd wl[0] wl[1] wl[2] wl[3] wl[4] wl[5] wl[6] wl[7] wl[8] wl[9] wl[10] wl[11] wl[12] wl[13] wl[14] wl[15] wl[16] wl[17] wl[18] wl[19] wl[20] wl[21] wl[22] wl[23] wl[24] wl[25] wl[26] wl[27] wl[28] wl[29] wl[30] wl[31] wl[32] wl[33] wl[34] wl[35] wl[36] wl[37] wl[38] wl[39] wl[40] wl[41] wl[42] wl[43] wl[44] wl[45] wl[46] wl[47] wl[48] wl[49] wl[50] wl[51] wl[52] wl[53] wl[54] wl[55] wl[56] wl[57] wl[58] wl[59] wl[60] wl[61] wl[62] wl[63] wl[64] wl[65] wl[66] wl[67] wl[68] wl[69] wl[70] wl[71] wl[72] wl[73] wl[74] wl[75] wl[76] wl[77] wl[78] wl[79] wl[80] wl[81] wl[82] wl[83] wl[84] wl[85] wl[86] wl[87] wl[88] wl[89] wl[90] wl[91] wl[92] wl[93] wl[94] wl[95] wl[96] wl[97] wl[98] wl[99] wl[100] wl[101] wl[102] wl[103] wl[104] wl[105] wl[106] wl[107] wl[108] wl[109] wl[110] wl[111] wl[112] wl[113] wl[114] wl[115] wl[116] wl[117] wl[118] wl[119] wl[120] wl[121] wl[122] wl[123] wl[124] wl[125] wl[126] wl[127] q[8] d[8] q[9] d[9] q[10] d[10] q[11] d[11] q[12] d[12] q[13] d[13] q[14] d[14] q[15] d[15] we[1] clk we_en precharge_n mux[0] mux[1] mux[2] mux[3] SP6T1Column_128R_CP8B_CM4MN26L580W1R_PC26L100W
Xcolumn[2] vss vdd wl[0] wl[1] wl[2] wl[3] wl[4] wl[5] wl[6] wl[7] wl[8] wl[9] wl[10] wl[11] wl[12] wl[13] wl[14] wl[15] wl[16] wl[17] wl[18] wl[19] wl[20] wl[21] wl[22] wl[23] wl[24] wl[25] wl[26] wl[27] wl[28] wl[29] wl[30] wl[31] wl[32] wl[33] wl[34] wl[35] wl[36] wl[37] wl[38] wl[39] wl[40] wl[41] wl[42] wl[43] wl[44] wl[45] wl[46] wl[47] wl[48] wl[49] wl[50] wl[51] wl[52] wl[53] wl[54] wl[55] wl[56] wl[57] wl[58] wl[59] wl[60] wl[61] wl[62] wl[63] wl[64] wl[65] wl[66] wl[67] wl[68] wl[69] wl[70] wl[71] wl[72] wl[73] wl[74] wl[75] wl[76] wl[77] wl[78] wl[79] wl[80] wl[81] wl[82] wl[83] wl[84] wl[85] wl[86] wl[87] wl[88] wl[89] wl[90] wl[91] wl[92] wl[93] wl[94] wl[95] wl[96] wl[97] wl[98] wl[99] wl[100] wl[101] wl[102] wl[103] wl[104] wl[105] wl[106] wl[107] wl[108] wl[109] wl[110] wl[111] wl[112] wl[113] wl[114] wl[115] wl[116] wl[117] wl[118] wl[119] wl[120] wl[121] wl[122] wl[123] wl[124] wl[125] wl[126] wl[127] q[16] d[16] q[17] d[17] q[18] d[18] q[19] d[19] q[20] d[20] q[21] d[21] q[22] d[22] q[23] d[23] we[2] clk we_en precharge_n mux[0] mux[1] mux[2] mux[3] SP6T1Column_128R_CP8B_CM4MN26L580W1R_PC26L100W
Xcolumn[3] vss vdd wl[0] wl[1] wl[2] wl[3] wl[4] wl[5] wl[6] wl[7] wl[8] wl[9] wl[10] wl[11] wl[12] wl[13] wl[14] wl[15] wl[16] wl[17] wl[18] wl[19] wl[20] wl[21] wl[22] wl[23] wl[24] wl[25] wl[26] wl[27] wl[28] wl[29] wl[30] wl[31] wl[32] wl[33] wl[34] wl[35] wl[36] wl[37] wl[38] wl[39] wl[40] wl[41] wl[42] wl[43] wl[44] wl[45] wl[46] wl[47] wl[48] wl[49] wl[50] wl[51] wl[52] wl[53] wl[54] wl[55] wl[56] wl[57] wl[58] wl[59] wl[60] wl[61] wl[62] wl[63] wl[64] wl[65] wl[66] wl[67] wl[68] wl[69] wl[70] wl[71] wl[72] wl[73] wl[74] wl[75] wl[76] wl[77] wl[78] wl[79] wl[80] wl[81] wl[82] wl[83] wl[84] wl[85] wl[86] wl[87] wl[88] wl[89] wl[90] wl[91] wl[92] wl[93] wl[94] wl[95] wl[96] wl[97] wl[98] wl[99] wl[100] wl[101] wl[102] wl[103] wl[104] wl[105] wl[106] wl[107] wl[108] wl[109] wl[110] wl[111] wl[112] wl[113] wl[114] wl[115] wl[116] wl[117] wl[118] wl[119] wl[120] wl[121] wl[122] wl[123] wl[124] wl[125] wl[126] wl[127] q[24] d[24] q[25] d[25] q[26] d[26] q[27] d[27] q[28] d[28] q[29] d[29] q[30] d[30] q[31] d[31] we[3] clk we_en precharge_n mux[0] mux[1] mux[2] mux[3] SP6T1Column_128R_CP8B_CM4MN26L580W1R_PC26L100W
.ends SP6T1ColumnBlock_COL128R_CP8B_CM4MN26L580W1R_PC26L100W_4WE

.subckt SP6T1WLDriver_N26L400WP26L800W vss substrate vdd nwell wl_n wl_drive
Xnmos1 vss wl_n wl_drive substrate sg13_lv_nmos l=1.3e-07 w=2e-06
Xnmos2 wl_drive wl_n vss substrate sg13_lv_nmos l=1.3e-07 w=2e-06
Xpmos1 vdd wl_n wl_drive nwell sg13_lv_pmos l=1.3e-07 w=4e-06
Xpmos2 wl_drive wl_n vdd nwell sg13_lv_pmos l=1.3e-07 w=4e-06
.ends SP6T1WLDriver_N26L400WP26L800W

.subckt SP6T1WLDriverBC_N26L400WP26L800W vss vdd
.ends SP6T1WLDriverBC_N26L400WP26L800W

.subckt SP6T1WLDriverCol_128RN26L400WP26L800W vss vdd wl[0] wl_n[0] wl[1] wl_n[1] wl[2] wl_n[2] wl[3] wl_n[3] wl[4] wl_n[4] wl[5] wl_n[5] wl[6] wl_n[6] wl[7] wl_n[7] wl[8] wl_n[8] wl[9] wl_n[9] wl[10] wl_n[10] wl[11] wl_n[11] wl[12] wl_n[12] wl[13] wl_n[13] wl[14] wl_n[14] wl[15] wl_n[15] wl[16] wl_n[16] wl[17] wl_n[17] wl[18] wl_n[18] wl[19] wl_n[19] wl[20] wl_n[20] wl[21] wl_n[21] wl[22] wl_n[22] wl[23] wl_n[23] wl[24] wl_n[24] wl[25] wl_n[25] wl[26] wl_n[26] wl[27] wl_n[27] wl[28] wl_n[28] wl[29] wl_n[29] wl[30] wl_n[30] wl[31] wl_n[31] wl[32] wl_n[32] wl[33] wl_n[33] wl[34] wl_n[34] wl[35] wl_n[35] wl[36] wl_n[36] wl[37] wl_n[37] wl[38] wl_n[38] wl[39] wl_n[39] wl[40] wl_n[40] wl[41] wl_n[41] wl[42] wl_n[42] wl[43] wl_n[43] wl[44] wl_n[44] wl[45] wl_n[45] wl[46] wl_n[46] wl[47] wl_n[47] wl[48] wl_n[48] wl[49] wl_n[49] wl[50] wl_n[50] wl[51] wl_n[51] wl[52] wl_n[52] wl[53] wl_n[53] wl[54] wl_n[54] wl[55] wl_n[55] wl[56] wl_n[56] wl[57] wl_n[57] wl[58] wl_n[58] wl[59] wl_n[59] wl[60] wl_n[60] wl[61] wl_n[61] wl[62] wl_n[62] wl[63] wl_n[63] wl[64] wl_n[64] wl[65] wl_n[65] wl[66] wl_n[66] wl[67] wl_n[67] wl[68] wl_n[68] wl[69] wl_n[69] wl[70] wl_n[70] wl[71] wl_n[71] wl[72] wl_n[72] wl[73] wl_n[73] wl[74] wl_n[74] wl[75] wl_n[75] wl[76] wl_n[76] wl[77] wl_n[77] wl[78] wl_n[78] wl[79] wl_n[79] wl[80] wl_n[80] wl[81] wl_n[81] wl[82] wl_n[82] wl[83] wl_n[83] wl[84] wl_n[84] wl[85] wl_n[85] wl[86] wl_n[86] wl[87] wl_n[87] wl[88] wl_n[88] wl[89] wl_n[89] wl[90] wl_n[90] wl[91] wl_n[91] wl[92] wl_n[92] wl[93] wl_n[93] wl[94] wl_n[94] wl[95] wl_n[95] wl[96] wl_n[96] wl[97] wl_n[97] wl[98] wl_n[98] wl[99] wl_n[99] wl[100] wl_n[100] wl[101] wl_n[101] wl[102] wl_n[102] wl[103] wl_n[103] wl[104] wl_n[104] wl[105] wl_n[105] wl[106] wl_n[106] wl[107] wl_n[107] wl[108] wl_n[108] wl[109] wl_n[109] wl[110] wl_n[110] wl[111] wl_n[111] wl[112] wl_n[112] wl[113] wl_n[113] wl[114] wl_n[114] wl[115] wl_n[115] wl[116] wl_n[116] wl[117] wl_n[117] wl[118] wl_n[118] wl[119] wl_n[119] wl[120] wl_n[120] wl[121] wl_n[121] wl[122] wl_n[122] wl[123] wl_n[123] wl[124] wl_n[124] wl[125] wl_n[125] wl[126] wl_n[126] wl[127] wl_n[127]
Xdriver[0] vss vss vdd vdd wl_n[0] wl[0] SP6T1WLDriver_N26L400WP26L800W
Xdriver[1] vss vss vdd vdd wl_n[1] wl[1] SP6T1WLDriver_N26L400WP26L800W
Xdriver[2] vss vss vdd vdd wl_n[2] wl[2] SP6T1WLDriver_N26L400WP26L800W
Xdriver[3] vss vss vdd vdd wl_n[3] wl[3] SP6T1WLDriver_N26L400WP26L800W
Xdriver[4] vss vss vdd vdd wl_n[4] wl[4] SP6T1WLDriver_N26L400WP26L800W
Xdriver[5] vss vss vdd vdd wl_n[5] wl[5] SP6T1WLDriver_N26L400WP26L800W
Xdriver[6] vss vss vdd vdd wl_n[6] wl[6] SP6T1WLDriver_N26L400WP26L800W
Xdriver[7] vss vss vdd vdd wl_n[7] wl[7] SP6T1WLDriver_N26L400WP26L800W
Xdriver[8] vss vss vdd vdd wl_n[8] wl[8] SP6T1WLDriver_N26L400WP26L800W
Xdriver[9] vss vss vdd vdd wl_n[9] wl[9] SP6T1WLDriver_N26L400WP26L800W
Xdriver[10] vss vss vdd vdd wl_n[10] wl[10] SP6T1WLDriver_N26L400WP26L800W
Xdriver[11] vss vss vdd vdd wl_n[11] wl[11] SP6T1WLDriver_N26L400WP26L800W
Xdriver[12] vss vss vdd vdd wl_n[12] wl[12] SP6T1WLDriver_N26L400WP26L800W
Xdriver[13] vss vss vdd vdd wl_n[13] wl[13] SP6T1WLDriver_N26L400WP26L800W
Xdriver[14] vss vss vdd vdd wl_n[14] wl[14] SP6T1WLDriver_N26L400WP26L800W
Xdriver[15] vss vss vdd vdd wl_n[15] wl[15] SP6T1WLDriver_N26L400WP26L800W
Xdriver[16] vss vss vdd vdd wl_n[16] wl[16] SP6T1WLDriver_N26L400WP26L800W
Xdriver[17] vss vss vdd vdd wl_n[17] wl[17] SP6T1WLDriver_N26L400WP26L800W
Xdriver[18] vss vss vdd vdd wl_n[18] wl[18] SP6T1WLDriver_N26L400WP26L800W
Xdriver[19] vss vss vdd vdd wl_n[19] wl[19] SP6T1WLDriver_N26L400WP26L800W
Xdriver[20] vss vss vdd vdd wl_n[20] wl[20] SP6T1WLDriver_N26L400WP26L800W
Xdriver[21] vss vss vdd vdd wl_n[21] wl[21] SP6T1WLDriver_N26L400WP26L800W
Xdriver[22] vss vss vdd vdd wl_n[22] wl[22] SP6T1WLDriver_N26L400WP26L800W
Xdriver[23] vss vss vdd vdd wl_n[23] wl[23] SP6T1WLDriver_N26L400WP26L800W
Xdriver[24] vss vss vdd vdd wl_n[24] wl[24] SP6T1WLDriver_N26L400WP26L800W
Xdriver[25] vss vss vdd vdd wl_n[25] wl[25] SP6T1WLDriver_N26L400WP26L800W
Xdriver[26] vss vss vdd vdd wl_n[26] wl[26] SP6T1WLDriver_N26L400WP26L800W
Xdriver[27] vss vss vdd vdd wl_n[27] wl[27] SP6T1WLDriver_N26L400WP26L800W
Xdriver[28] vss vss vdd vdd wl_n[28] wl[28] SP6T1WLDriver_N26L400WP26L800W
Xdriver[29] vss vss vdd vdd wl_n[29] wl[29] SP6T1WLDriver_N26L400WP26L800W
Xdriver[30] vss vss vdd vdd wl_n[30] wl[30] SP6T1WLDriver_N26L400WP26L800W
Xdriver[31] vss vss vdd vdd wl_n[31] wl[31] SP6T1WLDriver_N26L400WP26L800W
Xdriver[32] vss vss vdd vdd wl_n[32] wl[32] SP6T1WLDriver_N26L400WP26L800W
Xdriver[33] vss vss vdd vdd wl_n[33] wl[33] SP6T1WLDriver_N26L400WP26L800W
Xdriver[34] vss vss vdd vdd wl_n[34] wl[34] SP6T1WLDriver_N26L400WP26L800W
Xdriver[35] vss vss vdd vdd wl_n[35] wl[35] SP6T1WLDriver_N26L400WP26L800W
Xdriver[36] vss vss vdd vdd wl_n[36] wl[36] SP6T1WLDriver_N26L400WP26L800W
Xdriver[37] vss vss vdd vdd wl_n[37] wl[37] SP6T1WLDriver_N26L400WP26L800W
Xdriver[38] vss vss vdd vdd wl_n[38] wl[38] SP6T1WLDriver_N26L400WP26L800W
Xdriver[39] vss vss vdd vdd wl_n[39] wl[39] SP6T1WLDriver_N26L400WP26L800W
Xdriver[40] vss vss vdd vdd wl_n[40] wl[40] SP6T1WLDriver_N26L400WP26L800W
Xdriver[41] vss vss vdd vdd wl_n[41] wl[41] SP6T1WLDriver_N26L400WP26L800W
Xdriver[42] vss vss vdd vdd wl_n[42] wl[42] SP6T1WLDriver_N26L400WP26L800W
Xdriver[43] vss vss vdd vdd wl_n[43] wl[43] SP6T1WLDriver_N26L400WP26L800W
Xdriver[44] vss vss vdd vdd wl_n[44] wl[44] SP6T1WLDriver_N26L400WP26L800W
Xdriver[45] vss vss vdd vdd wl_n[45] wl[45] SP6T1WLDriver_N26L400WP26L800W
Xdriver[46] vss vss vdd vdd wl_n[46] wl[46] SP6T1WLDriver_N26L400WP26L800W
Xdriver[47] vss vss vdd vdd wl_n[47] wl[47] SP6T1WLDriver_N26L400WP26L800W
Xdriver[48] vss vss vdd vdd wl_n[48] wl[48] SP6T1WLDriver_N26L400WP26L800W
Xdriver[49] vss vss vdd vdd wl_n[49] wl[49] SP6T1WLDriver_N26L400WP26L800W
Xdriver[50] vss vss vdd vdd wl_n[50] wl[50] SP6T1WLDriver_N26L400WP26L800W
Xdriver[51] vss vss vdd vdd wl_n[51] wl[51] SP6T1WLDriver_N26L400WP26L800W
Xdriver[52] vss vss vdd vdd wl_n[52] wl[52] SP6T1WLDriver_N26L400WP26L800W
Xdriver[53] vss vss vdd vdd wl_n[53] wl[53] SP6T1WLDriver_N26L400WP26L800W
Xdriver[54] vss vss vdd vdd wl_n[54] wl[54] SP6T1WLDriver_N26L400WP26L800W
Xdriver[55] vss vss vdd vdd wl_n[55] wl[55] SP6T1WLDriver_N26L400WP26L800W
Xdriver[56] vss vss vdd vdd wl_n[56] wl[56] SP6T1WLDriver_N26L400WP26L800W
Xdriver[57] vss vss vdd vdd wl_n[57] wl[57] SP6T1WLDriver_N26L400WP26L800W
Xdriver[58] vss vss vdd vdd wl_n[58] wl[58] SP6T1WLDriver_N26L400WP26L800W
Xdriver[59] vss vss vdd vdd wl_n[59] wl[59] SP6T1WLDriver_N26L400WP26L800W
Xdriver[60] vss vss vdd vdd wl_n[60] wl[60] SP6T1WLDriver_N26L400WP26L800W
Xdriver[61] vss vss vdd vdd wl_n[61] wl[61] SP6T1WLDriver_N26L400WP26L800W
Xdriver[62] vss vss vdd vdd wl_n[62] wl[62] SP6T1WLDriver_N26L400WP26L800W
Xdriver[63] vss vss vdd vdd wl_n[63] wl[63] SP6T1WLDriver_N26L400WP26L800W
Xdriver[64] vss vss vdd vdd wl_n[64] wl[64] SP6T1WLDriver_N26L400WP26L800W
Xdriver[65] vss vss vdd vdd wl_n[65] wl[65] SP6T1WLDriver_N26L400WP26L800W
Xdriver[66] vss vss vdd vdd wl_n[66] wl[66] SP6T1WLDriver_N26L400WP26L800W
Xdriver[67] vss vss vdd vdd wl_n[67] wl[67] SP6T1WLDriver_N26L400WP26L800W
Xdriver[68] vss vss vdd vdd wl_n[68] wl[68] SP6T1WLDriver_N26L400WP26L800W
Xdriver[69] vss vss vdd vdd wl_n[69] wl[69] SP6T1WLDriver_N26L400WP26L800W
Xdriver[70] vss vss vdd vdd wl_n[70] wl[70] SP6T1WLDriver_N26L400WP26L800W
Xdriver[71] vss vss vdd vdd wl_n[71] wl[71] SP6T1WLDriver_N26L400WP26L800W
Xdriver[72] vss vss vdd vdd wl_n[72] wl[72] SP6T1WLDriver_N26L400WP26L800W
Xdriver[73] vss vss vdd vdd wl_n[73] wl[73] SP6T1WLDriver_N26L400WP26L800W
Xdriver[74] vss vss vdd vdd wl_n[74] wl[74] SP6T1WLDriver_N26L400WP26L800W
Xdriver[75] vss vss vdd vdd wl_n[75] wl[75] SP6T1WLDriver_N26L400WP26L800W
Xdriver[76] vss vss vdd vdd wl_n[76] wl[76] SP6T1WLDriver_N26L400WP26L800W
Xdriver[77] vss vss vdd vdd wl_n[77] wl[77] SP6T1WLDriver_N26L400WP26L800W
Xdriver[78] vss vss vdd vdd wl_n[78] wl[78] SP6T1WLDriver_N26L400WP26L800W
Xdriver[79] vss vss vdd vdd wl_n[79] wl[79] SP6T1WLDriver_N26L400WP26L800W
Xdriver[80] vss vss vdd vdd wl_n[80] wl[80] SP6T1WLDriver_N26L400WP26L800W
Xdriver[81] vss vss vdd vdd wl_n[81] wl[81] SP6T1WLDriver_N26L400WP26L800W
Xdriver[82] vss vss vdd vdd wl_n[82] wl[82] SP6T1WLDriver_N26L400WP26L800W
Xdriver[83] vss vss vdd vdd wl_n[83] wl[83] SP6T1WLDriver_N26L400WP26L800W
Xdriver[84] vss vss vdd vdd wl_n[84] wl[84] SP6T1WLDriver_N26L400WP26L800W
Xdriver[85] vss vss vdd vdd wl_n[85] wl[85] SP6T1WLDriver_N26L400WP26L800W
Xdriver[86] vss vss vdd vdd wl_n[86] wl[86] SP6T1WLDriver_N26L400WP26L800W
Xdriver[87] vss vss vdd vdd wl_n[87] wl[87] SP6T1WLDriver_N26L400WP26L800W
Xdriver[88] vss vss vdd vdd wl_n[88] wl[88] SP6T1WLDriver_N26L400WP26L800W
Xdriver[89] vss vss vdd vdd wl_n[89] wl[89] SP6T1WLDriver_N26L400WP26L800W
Xdriver[90] vss vss vdd vdd wl_n[90] wl[90] SP6T1WLDriver_N26L400WP26L800W
Xdriver[91] vss vss vdd vdd wl_n[91] wl[91] SP6T1WLDriver_N26L400WP26L800W
Xdriver[92] vss vss vdd vdd wl_n[92] wl[92] SP6T1WLDriver_N26L400WP26L800W
Xdriver[93] vss vss vdd vdd wl_n[93] wl[93] SP6T1WLDriver_N26L400WP26L800W
Xdriver[94] vss vss vdd vdd wl_n[94] wl[94] SP6T1WLDriver_N26L400WP26L800W
Xdriver[95] vss vss vdd vdd wl_n[95] wl[95] SP6T1WLDriver_N26L400WP26L800W
Xdriver[96] vss vss vdd vdd wl_n[96] wl[96] SP6T1WLDriver_N26L400WP26L800W
Xdriver[97] vss vss vdd vdd wl_n[97] wl[97] SP6T1WLDriver_N26L400WP26L800W
Xdriver[98] vss vss vdd vdd wl_n[98] wl[98] SP6T1WLDriver_N26L400WP26L800W
Xdriver[99] vss vss vdd vdd wl_n[99] wl[99] SP6T1WLDriver_N26L400WP26L800W
Xdriver[100] vss vss vdd vdd wl_n[100] wl[100] SP6T1WLDriver_N26L400WP26L800W
Xdriver[101] vss vss vdd vdd wl_n[101] wl[101] SP6T1WLDriver_N26L400WP26L800W
Xdriver[102] vss vss vdd vdd wl_n[102] wl[102] SP6T1WLDriver_N26L400WP26L800W
Xdriver[103] vss vss vdd vdd wl_n[103] wl[103] SP6T1WLDriver_N26L400WP26L800W
Xdriver[104] vss vss vdd vdd wl_n[104] wl[104] SP6T1WLDriver_N26L400WP26L800W
Xdriver[105] vss vss vdd vdd wl_n[105] wl[105] SP6T1WLDriver_N26L400WP26L800W
Xdriver[106] vss vss vdd vdd wl_n[106] wl[106] SP6T1WLDriver_N26L400WP26L800W
Xdriver[107] vss vss vdd vdd wl_n[107] wl[107] SP6T1WLDriver_N26L400WP26L800W
Xdriver[108] vss vss vdd vdd wl_n[108] wl[108] SP6T1WLDriver_N26L400WP26L800W
Xdriver[109] vss vss vdd vdd wl_n[109] wl[109] SP6T1WLDriver_N26L400WP26L800W
Xdriver[110] vss vss vdd vdd wl_n[110] wl[110] SP6T1WLDriver_N26L400WP26L800W
Xdriver[111] vss vss vdd vdd wl_n[111] wl[111] SP6T1WLDriver_N26L400WP26L800W
Xdriver[112] vss vss vdd vdd wl_n[112] wl[112] SP6T1WLDriver_N26L400WP26L800W
Xdriver[113] vss vss vdd vdd wl_n[113] wl[113] SP6T1WLDriver_N26L400WP26L800W
Xdriver[114] vss vss vdd vdd wl_n[114] wl[114] SP6T1WLDriver_N26L400WP26L800W
Xdriver[115] vss vss vdd vdd wl_n[115] wl[115] SP6T1WLDriver_N26L400WP26L800W
Xdriver[116] vss vss vdd vdd wl_n[116] wl[116] SP6T1WLDriver_N26L400WP26L800W
Xdriver[117] vss vss vdd vdd wl_n[117] wl[117] SP6T1WLDriver_N26L400WP26L800W
Xdriver[118] vss vss vdd vdd wl_n[118] wl[118] SP6T1WLDriver_N26L400WP26L800W
Xdriver[119] vss vss vdd vdd wl_n[119] wl[119] SP6T1WLDriver_N26L400WP26L800W
Xdriver[120] vss vss vdd vdd wl_n[120] wl[120] SP6T1WLDriver_N26L400WP26L800W
Xdriver[121] vss vss vdd vdd wl_n[121] wl[121] SP6T1WLDriver_N26L400WP26L800W
Xdriver[122] vss vss vdd vdd wl_n[122] wl[122] SP6T1WLDriver_N26L400WP26L800W
Xdriver[123] vss vss vdd vdd wl_n[123] wl[123] SP6T1WLDriver_N26L400WP26L800W
Xdriver[124] vss vss vdd vdd wl_n[124] wl[124] SP6T1WLDriver_N26L400WP26L800W
Xdriver[125] vss vss vdd vdd wl_n[125] wl[125] SP6T1WLDriver_N26L400WP26L800W
Xdriver[126] vss vss vdd vdd wl_n[126] wl[126] SP6T1WLDriver_N26L400WP26L800W
Xdriver[127] vss vss vdd vdd wl_n[127] wl[127] SP6T1WLDriver_N26L400WP26L800W
Xbc[0] vss vdd SP6T1WLDriverBC_N26L400WP26L800W
Xbc[1] vss vdd SP6T1WLDriverBC_N26L400WP26L800W
Xbc[2] vss vdd SP6T1WLDriverBC_N26L400WP26L800W
Xbc[3] vss vdd SP6T1WLDriverBC_N26L400WP26L800W
Xbc[4] vss vdd SP6T1WLDriverBC_N26L400WP26L800W
Xbc[5] vss vdd SP6T1WLDriverBC_N26L400WP26L800W
Xbc[6] vss vdd SP6T1WLDriverBC_N26L400WP26L800W
Xbc[7] vss vdd SP6T1WLDriverBC_N26L400WP26L800W
Xbc[8] vss vdd SP6T1WLDriverBC_N26L400WP26L800W
.ends SP6T1WLDriverCol_128RN26L400WP26L800W

.subckt SP6T1NonOvlClock_4S11341D1R vss vdd clk firststage[0] firststage[1] firststage[2] firststage[3] firststage[4] secondstage[0] secondstage[1] secondstage[2] secondstage[3] secondstage[4]
Xclkinv vdd vss clk clk_n inv_x0
Xfirstnand2 vdd vss firststage[0] clk secondstage[4] nand2_x0
Xfirststage[0] vdd vss firststage[0] firststage[1] inv_x0
Xfirststage[1] vdd vss firststage[1] firststage[2] inv_x0
Xfirststage[2] vdd vss firststage[2] firststage[3] inv_x0
Xfirststage[3] vdd vss firststage[3] firststage[4] inv_x0
Xsecondnand2 vdd vss secondstage[0] clk_n firststage[4] nand2_x0
Xsecondstage[0] vdd vss secondstage[0] secondstage[1] inv_x0
Xsecondstage[1] vdd vss secondstage[1] secondstage[2] inv_x0
Xsecondstage[2] vdd vss secondstage[2] secondstage[3] inv_x0
Xsecondstage[3] vdd vss secondstage[3] secondstage[4] inv_x0
.ends SP6T1NonOvlClock_4S11341D1R

.subckt buf_x1 vdd vss i q
Xstage0_nmos _i_n i vss vss sg13_lv_nmos l=1.3e-07 w=7.8e-07
Xstage0_pmos _i_n i vdd vdd sg13_lv_pmos l=1.3e-07 w=7.8e-07
Xnmos vss _i_n q vss sg13_lv_nmos l=1.3e-07 w=1.07e-06
Xpmos vdd _i_n q vdd sg13_lv_pmos l=1.3e-07 w=1.06e-06
.ends buf_x1

.subckt inv_x3 vdd vss i nq
Xnmos[0] vss i nq vss sg13_lv_nmos l=1.3e-07 w=1.46e-06
Xpmos[0] vdd i nq vdd sg13_lv_pmos l=1.3e-07 w=1.45e-06
Xnmos[1] nq i vss vss sg13_lv_nmos l=1.3e-07 w=1.46e-06
Xpmos[1] nq i vdd vdd sg13_lv_pmos l=1.3e-07 w=1.45e-06
Xnmos[2] vss i nq vss sg13_lv_nmos l=1.3e-07 w=1.46e-06
Xpmos[2] vdd i nq vdd sg13_lv_pmos l=1.3e-07 w=1.45e-06
.ends inv_x3

.subckt buf_x4 vdd vss i q
Xstage0_nmos _i_n i vss vss sg13_lv_nmos l=1.3e-07 w=1.07e-06
Xstage0_pmos _i_n i vdd vdd sg13_lv_pmos l=1.3e-07 w=1.06e-06
Xnmos[0] vss _i_n q vss sg13_lv_nmos l=1.3e-07 w=1.07e-06
Xpmos[0] vdd _i_n q vdd sg13_lv_pmos l=1.3e-07 w=1.06e-06
Xnmos[1] q _i_n vss vss sg13_lv_nmos l=1.3e-07 w=1.07e-06
Xpmos[1] q _i_n vdd vdd sg13_lv_pmos l=1.3e-07 w=1.06e-06
Xnmos[2] vss _i_n q vss sg13_lv_nmos l=1.3e-07 w=1.07e-06
Xpmos[2] vdd _i_n q vdd sg13_lv_pmos l=1.3e-07 w=1.06e-06
Xnmos[3] q _i_n vss vss sg13_lv_nmos l=1.3e-07 w=1.07e-06
Xpmos[3] q _i_n vdd vdd sg13_lv_pmos l=1.3e-07 w=1.06e-06
.ends buf_x4

.subckt SP6T1ClockGen_4S11341D1R vss vdd clk wl_en decodeclk columnclk precharge_n we_en
Xnonovl vss vdd clk firststage[0] firststage[1] firststage[2] firstpulse firststage[4] secondstage[0] secondstage[1] secondstage[2] secondpulse secondstage[4] SP6T1NonOvlClock_4S11341D1R
Xdecodeclkbuf vdd vss clk decodeclk buf_x1
Xcolumnclkbuf vdd vss clk columnclk buf_x1
Xprechargeinv vdd vss secondpulse precharge_n inv_x3
Xwlenbuf vdd vss firstpulse wl_en buf_x4
Xweenbuf vdd vss firstpulse we_en buf_x1
.ends SP6T1ClockGen_4S11341D1R

.subckt SP6T1Dec_dff_x1 vdd vss i clk q
Xclk_nmos _clk_n clk vss vss sg13_lv_nmos l=1.3e-07 w=7.8e-07
Xclk_pmos _clk_n clk vdd vdd sg13_lv_pmos l=1.3e-07 w=1.2e-06
Xclk_n_nmos0 vss _clk_n _clk_buf vss sg13_lv_nmos l=1.3e-07 w=7.8e-07
Xclk_n_pmos0 vdd _clk_n _clk_buf vdd sg13_lv_pmos l=1.3e-07 w=1.2e-06
Xi_nmos _u i vss vss sg13_lv_nmos l=1.3e-07 w=7.8e-07
Xi_pmos _u i vdd vdd sg13_lv_pmos l=1.3e-07 w=1.2e-06
Xu_nmos vss _u _net0 vss sg13_lv_nmos l=1.3e-07 w=7.8e-07
Xu_pmos vdd _u _net1 vdd sg13_lv_pmos l=1.3e-07 w=1.2e-06
Xclk_n_nmos1 _net0 _clk_n _dff_m vss sg13_lv_nmos l=1.3e-07 w=7.8e-07
Xclk_buf_pmos0 _net1 _clk_buf _dff_m vdd sg13_lv_pmos l=1.3e-07 w=1.2e-06
Xclk_buf_nmos0 _dff_m _clk_buf _net2 vss sg13_lv_nmos l=1.3e-07 w=7.8e-07
Xclk_n_pmos1 _dff_m _clk_n _net3 vdd sg13_lv_pmos l=1.3e-07 w=1.2e-06
Xy_nmos _net2 _y vss vss sg13_lv_nmos l=1.3e-07 w=7.8e-07
Xy_pmos _net3 _y vdd vdd sg13_lv_pmos l=1.3e-07 w=1.2e-06
Xdff_m_nmos vss _dff_m _y vss sg13_lv_nmos l=1.3e-07 w=7.8e-07
Xdff_m_pmos vdd _dff_m _y vdd sg13_lv_pmos l=1.3e-07 w=1.2e-06
Xclk_buf_nmos1 _y _clk_buf _dff_s vss sg13_lv_nmos l=1.3e-07 w=7.8e-07
Xclk_n_pmos2 _y _clk_n _dff_s vdd sg13_lv_pmos l=1.3e-07 w=1.2e-06
Xclk_n_nmos2 _dff_s _clk_n _net4 vss sg13_lv_nmos l=1.3e-07 w=7.8e-07
Xclk_buf_pmos1 _dff_s _clk_buf _net5 vdd sg13_lv_pmos l=1.3e-07 w=1.2e-06
Xq_nmos _net4 q vss vss sg13_lv_nmos l=1.3e-07 w=7.8e-07
Xq_pmos _net5 q vdd vdd sg13_lv_pmos l=1.3e-07 w=1.2e-06
Xdff_s_nmos vss _dff_s q vss sg13_lv_nmos l=1.3e-07 w=2.17e-06
Xdff_s_pmos vdd _dff_s q vdd sg13_lv_pmos l=1.3e-07 w=3.77e-06
.ends SP6T1Dec_dff_x1

.subckt SP6T1Dec_inv_x1 vdd vss i nq
Xnmos vss i nq vss sg13_lv_nmos l=1.3e-07 w=2.8e-06
Xpmos vdd i nq vdd sg13_lv_pmos l=1.3e-07 w=4.4e-06
.ends SP6T1Dec_inv_x1

.subckt SP6T1Dec_nand2_x0 vdd vss nq i0 i1
Xi0_nmos vss i0 _net0 vss sg13_lv_nmos l=1.3e-07 w=7.8e-07
Xi0_pmos vdd i0 nq vdd sg13_lv_pmos l=1.3e-07 w=1.2e-06
Xi1_nmos _net0 i1 nq vss sg13_lv_nmos l=1.3e-07 w=7.8e-07
Xi1_pmos nq i1 vdd vdd sg13_lv_pmos l=1.3e-07 w=1.2e-06
.ends SP6T1Dec_nand2_x0

.subckt SP6T1Dec_inv_x2 vdd vss i nq
Xnmos[0] vss i nq vss sg13_lv_nmos l=1.3e-07 w=2.8e-06
Xpmos[0] vdd i nq vdd sg13_lv_pmos l=1.3e-07 w=4.4e-06
Xnmos[1] nq i vss vss sg13_lv_nmos l=1.3e-07 w=2.8e-06
Xpmos[1] nq i vdd vdd sg13_lv_pmos l=1.3e-07 w=4.4e-06
.ends SP6T1Dec_inv_x2

.subckt SP6T1DirectColDec_A2B2R vss vdd clk a[0] a[1] line[0] line[1] line[2] line[3]
Xaff[0] vdd vss a[0] clk aint[0] SP6T1Dec_dff_x1
Xaff[1] vdd vss a[1] clk aint[1] SP6T1Dec_dff_x1
Xainv[0] vdd vss aint[0] aint_n[0] SP6T1Dec_inv_x1
Xainv[1] vdd vss aint[1] aint_n[1] SP6T1Dec_inv_x1
Xlinenand[0] vdd vss line_n[0] aint_n[0] aint_n[1] SP6T1Dec_nand2_x0
Xlinenand[1] vdd vss line_n[1] aint[0] aint_n[1] SP6T1Dec_nand2_x0
Xlinenand[2] vdd vss line_n[2] aint_n[0] aint[1] SP6T1Dec_nand2_x0
Xlinenand[3] vdd vss line_n[3] aint[0] aint[1] SP6T1Dec_nand2_x0
Xlineinv[0] vdd vss line_n[0] line[0] SP6T1Dec_inv_x2
Xlineinv[1] vdd vss line_n[1] line[1] SP6T1Dec_inv_x2
Xlineinv[2] vdd vss line_n[2] line[2] SP6T1Dec_inv_x2
Xlineinv[3] vdd vss line_n[3] line[3] SP6T1Dec_inv_x2
.ends SP6T1DirectColDec_A2B2R

.subckt SP6T1Dec_and3_x1 vdd vss q i0 i1 i2
Xi0_nmos nq i0 _net0 vss sg13_lv_nmos l=1.3e-07 w=7.8e-07
Xi0_pmos nq i0 vdd vdd sg13_lv_pmos l=1.3e-07 w=1.2e-06
Xi1_nmos _net0 i1 _net1 vss sg13_lv_nmos l=1.3e-07 w=7.8e-07
Xi1_pmos vdd i1 nq vdd sg13_lv_pmos l=1.3e-07 w=1.2e-06
Xi2_nmos _net1 i2 vss vss sg13_lv_nmos l=1.3e-07 w=7.8e-07
Xi2_pmos nq i2 vdd vdd sg13_lv_pmos l=1.3e-07 w=1.2e-06
Xn_pd vss nq q vss sg13_lv_nmos l=1.3e-07 w=2.8e-06
Xq_pu vdd nq q vdd sg13_lv_pmos l=1.3e-07 w=4.4e-06
.ends SP6T1Dec_and3_x1

.subckt SP6T1Dec_and4_x1 vdd vss q i0 i1 i2 i3
Xi0_nmos nq i0 _net0 vss sg13_lv_nmos l=1.3e-07 w=7.8e-07
Xi0_pmos vdd i0 nq vdd sg13_lv_pmos l=1.3e-07 w=1.2e-06
Xi1_nmos _net0 i1 _net1 vss sg13_lv_nmos l=1.3e-07 w=7.8e-07
Xi1_pmos nq i1 vdd vdd sg13_lv_pmos l=1.3e-07 w=1.2e-06
Xi2_nmos _net1 i2 _net2 vss sg13_lv_nmos l=1.3e-07 w=7.8e-07
Xi2_pmos vdd i2 nq vdd sg13_lv_pmos l=1.3e-07 w=1.2e-06
Xi3_nmos _net2 i3 vss vss sg13_lv_nmos l=1.3e-07 w=7.8e-07
Xi3_pmos nq i3 vdd vdd sg13_lv_pmos l=1.3e-07 w=1.2e-06
Xn_pd vss nq q vss sg13_lv_nmos l=1.3e-07 w=2.8e-06
Xq_pu vdd nq q vdd sg13_lv_pmos l=1.3e-07 w=4.4e-06
.ends SP6T1Dec_and4_x1

.subckt SP6T1Dec_tie_diff_w4 vdd vss
.ends SP6T1Dec_tie_diff_w4

.subckt SP6T1RowPredecoders_A3B4B vss vdd clk a[0] a[1] a[2] a[3] a[4] a[5] a[6] pd[0][0] pd[0][1] pd[0][2] pd[0][3] pd[0][4] pd[0][5] pd[0][6] pd[0][7] page[0] page[1] page[2] page[3] page[4] page[5] page[6] page[7] page[8] page[9] page[10] page[11] page[12] page[13] page[14] page[15]
Xaff[0] vdd vss a[0] clk aint[0] SP6T1Dec_dff_x1
Xaff[1] vdd vss a[1] clk aint[1] SP6T1Dec_dff_x1
Xaff[2] vdd vss a[2] clk aint[2] SP6T1Dec_dff_x1
Xaff[3] vdd vss a[3] clk aint[3] SP6T1Dec_dff_x1
Xaff[4] vdd vss a[4] clk aint[4] SP6T1Dec_dff_x1
Xaff[5] vdd vss a[5] clk aint[5] SP6T1Dec_dff_x1
Xaff[6] vdd vss a[6] clk aint[6] SP6T1Dec_dff_x1
Xainv[0] vdd vss aint[0] aint_n[0] SP6T1Dec_inv_x1
Xainv[1] vdd vss aint[1] aint_n[1] SP6T1Dec_inv_x1
Xainv[2] vdd vss aint[2] aint_n[2] SP6T1Dec_inv_x1
Xainv[3] vdd vss aint[3] aint_n[3] SP6T1Dec_inv_x1
Xainv[4] vdd vss aint[4] aint_n[4] SP6T1Dec_inv_x1
Xainv[5] vdd vss aint[5] aint_n[5] SP6T1Dec_inv_x1
Xainv[6] vdd vss aint[6] aint_n[6] SP6T1Dec_inv_x1
Xpd[0]and[0] vdd vss pd[0][0] aint_n[0] aint_n[1] aint_n[2] SP6T1Dec_and3_x1
Xpd[0]and[1] vdd vss pd[0][1] aint[0] aint_n[1] aint_n[2] SP6T1Dec_and3_x1
Xpd[0]and[2] vdd vss pd[0][2] aint_n[0] aint[1] aint_n[2] SP6T1Dec_and3_x1
Xpd[0]and[3] vdd vss pd[0][3] aint[0] aint[1] aint_n[2] SP6T1Dec_and3_x1
Xpd[0]and[4] vdd vss pd[0][4] aint_n[0] aint_n[1] aint[2] SP6T1Dec_and3_x1
Xpd[0]and[5] vdd vss pd[0][5] aint[0] aint_n[1] aint[2] SP6T1Dec_and3_x1
Xpd[0]and[6] vdd vss pd[0][6] aint_n[0] aint[1] aint[2] SP6T1Dec_and3_x1
Xpd[0]and[7] vdd vss pd[0][7] aint[0] aint[1] aint[2] SP6T1Dec_and3_x1
Xpage_and[0] vdd vss page[0] aint_n[3] aint_n[4] aint_n[5] aint_n[6] SP6T1Dec_and4_x1
Xpage_and[1] vdd vss page[1] aint[3] aint_n[4] aint_n[5] aint_n[6] SP6T1Dec_and4_x1
Xpage_and[2] vdd vss page[2] aint_n[3] aint[4] aint_n[5] aint_n[6] SP6T1Dec_and4_x1
Xpage_and[3] vdd vss page[3] aint[3] aint[4] aint_n[5] aint_n[6] SP6T1Dec_and4_x1
Xpage_and[4] vdd vss page[4] aint_n[3] aint_n[4] aint[5] aint_n[6] SP6T1Dec_and4_x1
Xpage_and[5] vdd vss page[5] aint[3] aint_n[4] aint[5] aint_n[6] SP6T1Dec_and4_x1
Xpage_and[6] vdd vss page[6] aint_n[3] aint[4] aint[5] aint_n[6] SP6T1Dec_and4_x1
Xpage_and[7] vdd vss page[7] aint[3] aint[4] aint[5] aint_n[6] SP6T1Dec_and4_x1
Xpage_and[8] vdd vss page[8] aint_n[3] aint_n[4] aint_n[5] aint[6] SP6T1Dec_and4_x1
Xpage_and[9] vdd vss page[9] aint[3] aint_n[4] aint_n[5] aint[6] SP6T1Dec_and4_x1
Xpage_and[10] vdd vss page[10] aint_n[3] aint[4] aint_n[5] aint[6] SP6T1Dec_and4_x1
Xpage_and[11] vdd vss page[11] aint[3] aint[4] aint_n[5] aint[6] SP6T1Dec_and4_x1
Xpage_and[12] vdd vss page[12] aint_n[3] aint_n[4] aint[5] aint[6] SP6T1Dec_and4_x1
Xpage_and[13] vdd vss page[13] aint[3] aint_n[4] aint[5] aint[6] SP6T1Dec_and4_x1
Xpage_and[14] vdd vss page[14] aint_n[3] aint[4] aint[5] aint[6] SP6T1Dec_and4_x1
Xpage_and[15] vdd vss page[15] aint[3] aint[4] aint[5] aint[6] SP6T1Dec_and4_x1
Xtie[0] vdd vss SP6T1Dec_tie_diff_w4
Xtie[1] vdd vss SP6T1Dec_tie_diff_w4
Xtie[2] vdd vss SP6T1Dec_tie_diff_w4
Xtie[3] vdd vss SP6T1Dec_tie_diff_w4
Xtie[4] vdd vss SP6T1Dec_tie_diff_w4
Xtie[5] vdd vss SP6T1Dec_tie_diff_w4
Xtie[6] vdd vss SP6T1Dec_tie_diff_w4
Xtie[7] vdd vss SP6T1Dec_tie_diff_w4
Xtie[8] vdd vss SP6T1Dec_tie_diff_w4
Xtie[9] vdd vss SP6T1Dec_tie_diff_w4
Xtie[10] vdd vss SP6T1Dec_tie_diff_w4
Xtie[11] vdd vss SP6T1Dec_tie_diff_w4
Xtie[12] vdd vss SP6T1Dec_tie_diff_w4
Xtie[13] vdd vss SP6T1Dec_tie_diff_w4
Xtie[14] vdd vss SP6T1Dec_tie_diff_w4
Xtie[15] vdd vss SP6T1Dec_tie_diff_w4
Xtie[16] vdd vss SP6T1Dec_tie_diff_w4
Xtie[17] vdd vss SP6T1Dec_tie_diff_w4
Xtie[18] vdd vss SP6T1Dec_tie_diff_w4
Xtie[19] vdd vss SP6T1Dec_tie_diff_w4
Xtie[20] vdd vss SP6T1Dec_tie_diff_w4
Xtie[21] vdd vss SP6T1Dec_tie_diff_w4
Xtie[22] vdd vss SP6T1Dec_tie_diff_w4
Xtie[23] vdd vss SP6T1Dec_tie_diff_w4
Xtie[24] vdd vss SP6T1Dec_tie_diff_w4
Xtie[24] vdd vss SP6T1Dec_tie_diff_w4
Xtie[24] vdd vss SP6T1Dec_tie_diff_w4
Xtie[24] vdd vss SP6T1Dec_tie_diff_w4
Xtie[24] vdd vss SP6T1Dec_tie_diff_w4
Xtie[24] vdd vss SP6T1Dec_tie_diff_w4
Xtie[24] vdd vss SP6T1Dec_tie_diff_w4
Xtie[24] vdd vss SP6T1Dec_tie_diff_w4
Xtie[24] vdd vss SP6T1Dec_tie_diff_w4
Xtie[24] vdd vss SP6T1Dec_tie_diff_w4
Xtie[24] vdd vss SP6T1Dec_tie_diff_w4
Xtie[24] vdd vss SP6T1Dec_tie_diff_w4
Xtie[24] vdd vss SP6T1Dec_tie_diff_w4
Xtie[24] vdd vss SP6T1Dec_tie_diff_w4
Xtie[24] vdd vss SP6T1Dec_tie_diff_w4
Xtie[24] vdd vss SP6T1Dec_tie_diff_w4
Xtie[24] vdd vss SP6T1Dec_tie_diff_w4
Xtie[24] vdd vss SP6T1Dec_tie_diff_w4
Xtie[24] vdd vss SP6T1Dec_tie_diff_w4
Xtie[24] vdd vss SP6T1Dec_tie_diff_w4
Xtie[24] vdd vss SP6T1Dec_tie_diff_w4
.ends SP6T1RowPredecoders_A3B4B

.subckt SP6T1RowDecoderNand3X2 vss vdd pd[0][0] pd[0][1] page wl_en wl_n[0] wl_n[1]
Xnmos[0] wl_n[0] wl_en int[0] vss sg13_lv_nmos l=1.3e-07 w=4.9e-07
Xnmos[1] int[0] pd[0][0] int[1] vss sg13_lv_nmos l=1.3e-07 w=4.9e-07
Xnmos[2] int[1] page vss vss sg13_lv_nmos l=1.3e-07 w=4.9e-07
Xnmos[3] vss page int[2] vss sg13_lv_nmos l=1.3e-07 w=4.9e-07
Xnmos[4] int[2] pd[0][1] int[3] vss sg13_lv_nmos l=1.3e-07 w=4.9e-07
Xnmos[5] int[3] wl_en wl_n[1] vss sg13_lv_nmos l=1.3e-07 w=4.9e-07
Xpmos[0] wl_n[0] wl_en vdd vdd sg13_lv_pmos l=1.3e-07 w=4.9e-07
Xpmos[1] vdd pd[0][0] wl_n[0] vdd sg13_lv_pmos l=1.3e-07 w=4.9e-07
Xpmos[2] wl_n[0] page vdd vdd sg13_lv_pmos l=1.3e-07 w=4.9e-07
Xpmos[3] vdd page wl_n[1] vdd sg13_lv_pmos l=1.3e-07 w=4.9e-07
Xpmos[4] wl_n[1] pd[0][1] vdd vdd sg13_lv_pmos l=1.3e-07 w=4.9e-07
Xpmos[5] vdd wl_en wl_n[1] vdd sg13_lv_pmos l=1.3e-07 w=4.9e-07
.ends SP6T1RowDecoderNand3X2

.subckt SP6T1RowDecPage_PD3B4BDH vss vdd pd[0][0] pd[0][1] wl_n[0] wl_n[1] pd[0][2] pd[0][3] wl_n[2] wl_n[3] pd[0][4] pd[0][5] wl_n[4] wl_n[5] pd[0][6] pd[0][7] wl_n[6] wl_n[7] page wl_en
Xnand3[0] vss vdd pd[0][0] pd[0][1] page wl_en wl_n[0] wl_n[1] SP6T1RowDecoderNand3X2
Xnand3[1] vss vdd pd[0][2] pd[0][3] page wl_en wl_n[2] wl_n[3] SP6T1RowDecoderNand3X2
Xnand3[2] vss vdd pd[0][4] pd[0][5] page wl_en wl_n[4] wl_n[5] SP6T1RowDecoderNand3X2
Xnand3[3] vss vdd pd[0][6] pd[0][7] page wl_en wl_n[6] wl_n[7] SP6T1RowDecoderNand3X2
.ends SP6T1RowDecPage_PD3B4BDH

.subckt SP6T1RowDecLastStageBC_N3DH vss vdd
.ends SP6T1RowDecLastStageBC_N3DH

.subckt SP6T1RowDec_PD3B4B_PAG3B4B0 vss vdd a[0] a[1] a[2] a[3] a[4] a[5] a[6] clk wl_en wl_n[0] wl_n[1] wl_n[2] wl_n[3] wl_n[4] wl_n[5] wl_n[6] wl_n[7] wl_n[8] wl_n[9] wl_n[10] wl_n[11] wl_n[12] wl_n[13] wl_n[14] wl_n[15] wl_n[16] wl_n[17] wl_n[18] wl_n[19] wl_n[20] wl_n[21] wl_n[22] wl_n[23] wl_n[24] wl_n[25] wl_n[26] wl_n[27] wl_n[28] wl_n[29] wl_n[30] wl_n[31] wl_n[32] wl_n[33] wl_n[34] wl_n[35] wl_n[36] wl_n[37] wl_n[38] wl_n[39] wl_n[40] wl_n[41] wl_n[42] wl_n[43] wl_n[44] wl_n[45] wl_n[46] wl_n[47] wl_n[48] wl_n[49] wl_n[50] wl_n[51] wl_n[52] wl_n[53] wl_n[54] wl_n[55] wl_n[56] wl_n[57] wl_n[58] wl_n[59] wl_n[60] wl_n[61] wl_n[62] wl_n[63] wl_n[64] wl_n[65] wl_n[66] wl_n[67] wl_n[68] wl_n[69] wl_n[70] wl_n[71] wl_n[72] wl_n[73] wl_n[74] wl_n[75] wl_n[76] wl_n[77] wl_n[78] wl_n[79] wl_n[80] wl_n[81] wl_n[82] wl_n[83] wl_n[84] wl_n[85] wl_n[86] wl_n[87] wl_n[88] wl_n[89] wl_n[90] wl_n[91] wl_n[92] wl_n[93] wl_n[94] wl_n[95] wl_n[96] wl_n[97] wl_n[98] wl_n[99] wl_n[100] wl_n[101] wl_n[102] wl_n[103] wl_n[104] wl_n[105] wl_n[106] wl_n[107] wl_n[108] wl_n[109] wl_n[110] wl_n[111] wl_n[112] wl_n[113] wl_n[114] wl_n[115] wl_n[116] wl_n[117] wl_n[118] wl_n[119] wl_n[120] wl_n[121] wl_n[122] wl_n[123] wl_n[124] wl_n[125] wl_n[126] wl_n[127]
Xpredec vss vdd clk a[0] a[1] a[2] a[3] a[4] a[5] a[6] pd[0][0] pd[0][1] pd[0][2] pd[0][3] pd[0][4] pd[0][5] pd[0][6] pd[0][7] page[0] page[1] page[2] page[3] page[4] page[5] page[6] page[7] page[8] page[9] page[10] page[11] page[12] page[13] page[14] page[15] SP6T1RowPredecoders_A3B4B
Xpage[0] vss vdd pd[0][0] pd[0][1] wl_n[0] wl_n[1] pd[0][2] pd[0][3] wl_n[2] wl_n[3] pd[0][4] pd[0][5] wl_n[4] wl_n[5] pd[0][6] pd[0][7] wl_n[6] wl_n[7] page[0] wl_en SP6T1RowDecPage_PD3B4BDH
Xpage[1] vss vdd pd[0][0] pd[0][1] wl_n[8] wl_n[9] pd[0][2] pd[0][3] wl_n[10] wl_n[11] pd[0][4] pd[0][5] wl_n[12] wl_n[13] pd[0][6] pd[0][7] wl_n[14] wl_n[15] page[1] wl_en SP6T1RowDecPage_PD3B4BDH
Xpage[2] vss vdd pd[0][0] pd[0][1] wl_n[16] wl_n[17] pd[0][2] pd[0][3] wl_n[18] wl_n[19] pd[0][4] pd[0][5] wl_n[20] wl_n[21] pd[0][6] pd[0][7] wl_n[22] wl_n[23] page[2] wl_en SP6T1RowDecPage_PD3B4BDH
Xpage[3] vss vdd pd[0][0] pd[0][1] wl_n[24] wl_n[25] pd[0][2] pd[0][3] wl_n[26] wl_n[27] pd[0][4] pd[0][5] wl_n[28] wl_n[29] pd[0][6] pd[0][7] wl_n[30] wl_n[31] page[3] wl_en SP6T1RowDecPage_PD3B4BDH
Xpage[4] vss vdd pd[0][0] pd[0][1] wl_n[32] wl_n[33] pd[0][2] pd[0][3] wl_n[34] wl_n[35] pd[0][4] pd[0][5] wl_n[36] wl_n[37] pd[0][6] pd[0][7] wl_n[38] wl_n[39] page[4] wl_en SP6T1RowDecPage_PD3B4BDH
Xpage[5] vss vdd pd[0][0] pd[0][1] wl_n[40] wl_n[41] pd[0][2] pd[0][3] wl_n[42] wl_n[43] pd[0][4] pd[0][5] wl_n[44] wl_n[45] pd[0][6] pd[0][7] wl_n[46] wl_n[47] page[5] wl_en SP6T1RowDecPage_PD3B4BDH
Xpage[6] vss vdd pd[0][0] pd[0][1] wl_n[48] wl_n[49] pd[0][2] pd[0][3] wl_n[50] wl_n[51] pd[0][4] pd[0][5] wl_n[52] wl_n[53] pd[0][6] pd[0][7] wl_n[54] wl_n[55] page[6] wl_en SP6T1RowDecPage_PD3B4BDH
Xpage[7] vss vdd pd[0][0] pd[0][1] wl_n[56] wl_n[57] pd[0][2] pd[0][3] wl_n[58] wl_n[59] pd[0][4] pd[0][5] wl_n[60] wl_n[61] pd[0][6] pd[0][7] wl_n[62] wl_n[63] page[7] wl_en SP6T1RowDecPage_PD3B4BDH
Xpage[8] vss vdd pd[0][0] pd[0][1] wl_n[64] wl_n[65] pd[0][2] pd[0][3] wl_n[66] wl_n[67] pd[0][4] pd[0][5] wl_n[68] wl_n[69] pd[0][6] pd[0][7] wl_n[70] wl_n[71] page[8] wl_en SP6T1RowDecPage_PD3B4BDH
Xpage[9] vss vdd pd[0][0] pd[0][1] wl_n[72] wl_n[73] pd[0][2] pd[0][3] wl_n[74] wl_n[75] pd[0][4] pd[0][5] wl_n[76] wl_n[77] pd[0][6] pd[0][7] wl_n[78] wl_n[79] page[9] wl_en SP6T1RowDecPage_PD3B4BDH
Xpage[10] vss vdd pd[0][0] pd[0][1] wl_n[80] wl_n[81] pd[0][2] pd[0][3] wl_n[82] wl_n[83] pd[0][4] pd[0][5] wl_n[84] wl_n[85] pd[0][6] pd[0][7] wl_n[86] wl_n[87] page[10] wl_en SP6T1RowDecPage_PD3B4BDH
Xpage[11] vss vdd pd[0][0] pd[0][1] wl_n[88] wl_n[89] pd[0][2] pd[0][3] wl_n[90] wl_n[91] pd[0][4] pd[0][5] wl_n[92] wl_n[93] pd[0][6] pd[0][7] wl_n[94] wl_n[95] page[11] wl_en SP6T1RowDecPage_PD3B4BDH
Xpage[12] vss vdd pd[0][0] pd[0][1] wl_n[96] wl_n[97] pd[0][2] pd[0][3] wl_n[98] wl_n[99] pd[0][4] pd[0][5] wl_n[100] wl_n[101] pd[0][6] pd[0][7] wl_n[102] wl_n[103] page[12] wl_en SP6T1RowDecPage_PD3B4BDH
Xpage[13] vss vdd pd[0][0] pd[0][1] wl_n[104] wl_n[105] pd[0][2] pd[0][3] wl_n[106] wl_n[107] pd[0][4] pd[0][5] wl_n[108] wl_n[109] pd[0][6] pd[0][7] wl_n[110] wl_n[111] page[13] wl_en SP6T1RowDecPage_PD3B4BDH
Xpage[14] vss vdd pd[0][0] pd[0][1] wl_n[112] wl_n[113] pd[0][2] pd[0][3] wl_n[114] wl_n[115] pd[0][4] pd[0][5] wl_n[116] wl_n[117] pd[0][6] pd[0][7] wl_n[118] wl_n[119] page[14] wl_en SP6T1RowDecPage_PD3B4BDH
Xpage[15] vss vdd pd[0][0] pd[0][1] wl_n[120] wl_n[121] pd[0][2] pd[0][3] wl_n[122] wl_n[123] pd[0][4] pd[0][5] wl_n[124] wl_n[125] pd[0][6] pd[0][7] wl_n[126] wl_n[127] page[15] wl_en SP6T1RowDecPage_PD3B4BDH
Xbulkcon[0] vss vdd SP6T1RowDecLastStageBC_N3DH
Xbulkcon[1] vss vdd SP6T1RowDecLastStageBC_N3DH
Xbulkcon[2] vss vdd SP6T1RowDecLastStageBC_N3DH
Xbulkcon[3] vss vdd SP6T1RowDecLastStageBC_N3DH
Xbulkcon[4] vss vdd SP6T1RowDecLastStageBC_N3DH
Xbulkcon[5] vss vdd SP6T1RowDecLastStageBC_N3DH
Xbulkcon[6] vss vdd SP6T1RowDecLastStageBC_N3DH
Xbulkcon[7] vss vdd SP6T1RowDecLastStageBC_N3DH
Xbulkcon[8] vss vdd SP6T1RowDecLastStageBC_N3DH
.ends SP6T1RowDec_PD3B4B_PAG3B4B0

.subckt SP6T1RowPeriph_PD3B4B_LD2B2R vss vdd a[0] a[1] a[2] a[3] a[4] a[5] a[6] a[7] a[8] wl_n[0] wl_n[1] wl_n[2] wl_n[3] wl_n[4] wl_n[5] wl_n[6] wl_n[7] wl_n[8] wl_n[9] wl_n[10] wl_n[11] wl_n[12] wl_n[13] wl_n[14] wl_n[15] wl_n[16] wl_n[17] wl_n[18] wl_n[19] wl_n[20] wl_n[21] wl_n[22] wl_n[23] wl_n[24] wl_n[25] wl_n[26] wl_n[27] wl_n[28] wl_n[29] wl_n[30] wl_n[31] wl_n[32] wl_n[33] wl_n[34] wl_n[35] wl_n[36] wl_n[37] wl_n[38] wl_n[39] wl_n[40] wl_n[41] wl_n[42] wl_n[43] wl_n[44] wl_n[45] wl_n[46] wl_n[47] wl_n[48] wl_n[49] wl_n[50] wl_n[51] wl_n[52] wl_n[53] wl_n[54] wl_n[55] wl_n[56] wl_n[57] wl_n[58] wl_n[59] wl_n[60] wl_n[61] wl_n[62] wl_n[63] wl_n[64] wl_n[65] wl_n[66] wl_n[67] wl_n[68] wl_n[69] wl_n[70] wl_n[71] wl_n[72] wl_n[73] wl_n[74] wl_n[75] wl_n[76] wl_n[77] wl_n[78] wl_n[79] wl_n[80] wl_n[81] wl_n[82] wl_n[83] wl_n[84] wl_n[85] wl_n[86] wl_n[87] wl_n[88] wl_n[89] wl_n[90] wl_n[91] wl_n[92] wl_n[93] wl_n[94] wl_n[95] wl_n[96] wl_n[97] wl_n[98] wl_n[99] wl_n[100] wl_n[101] wl_n[102] wl_n[103] wl_n[104] wl_n[105] wl_n[106] wl_n[107] wl_n[108] wl_n[109] wl_n[110] wl_n[111] wl_n[112] wl_n[113] wl_n[114] wl_n[115] wl_n[116] wl_n[117] wl_n[118] wl_n[119] wl_n[120] wl_n[121] wl_n[122] wl_n[123] wl_n[124] wl_n[125] wl_n[126] wl_n[127] decodeclk wl_en mux[0] mux[1] mux[2] mux[3]
Xcoldec vss vdd decodeclk a[0] a[1] mux[0] mux[1] mux[2] mux[3] SP6T1DirectColDec_A2B2R
Xrowdec vss vdd a[2] a[3] a[4] a[5] a[6] a[7] a[8] decodeclk wl_en wl_n[0] wl_n[1] wl_n[2] wl_n[3] wl_n[4] wl_n[5] wl_n[6] wl_n[7] wl_n[8] wl_n[9] wl_n[10] wl_n[11] wl_n[12] wl_n[13] wl_n[14] wl_n[15] wl_n[16] wl_n[17] wl_n[18] wl_n[19] wl_n[20] wl_n[21] wl_n[22] wl_n[23] wl_n[24] wl_n[25] wl_n[26] wl_n[27] wl_n[28] wl_n[29] wl_n[30] wl_n[31] wl_n[32] wl_n[33] wl_n[34] wl_n[35] wl_n[36] wl_n[37] wl_n[38] wl_n[39] wl_n[40] wl_n[41] wl_n[42] wl_n[43] wl_n[44] wl_n[45] wl_n[46] wl_n[47] wl_n[48] wl_n[49] wl_n[50] wl_n[51] wl_n[52] wl_n[53] wl_n[54] wl_n[55] wl_n[56] wl_n[57] wl_n[58] wl_n[59] wl_n[60] wl_n[61] wl_n[62] wl_n[63] wl_n[64] wl_n[65] wl_n[66] wl_n[67] wl_n[68] wl_n[69] wl_n[70] wl_n[71] wl_n[72] wl_n[73] wl_n[74] wl_n[75] wl_n[76] wl_n[77] wl_n[78] wl_n[79] wl_n[80] wl_n[81] wl_n[82] wl_n[83] wl_n[84] wl_n[85] wl_n[86] wl_n[87] wl_n[88] wl_n[89] wl_n[90] wl_n[91] wl_n[92] wl_n[93] wl_n[94] wl_n[95] wl_n[96] wl_n[97] wl_n[98] wl_n[99] wl_n[100] wl_n[101] wl_n[102] wl_n[103] wl_n[104] wl_n[105] wl_n[106] wl_n[107] wl_n[108] wl_n[109] wl_n[110] wl_n[111] wl_n[112] wl_n[113] wl_n[114] wl_n[115] wl_n[116] wl_n[117] wl_n[118] wl_n[119] wl_n[120] wl_n[121] wl_n[122] wl_n[123] wl_n[124] wl_n[125] wl_n[126] wl_n[127] SP6T1RowDec_PD3B4B_PAG3B4B0
.ends SP6T1RowPeriph_PD3B4B_LD2B2R

.subckt SP6T1Block_512x32_4we_C2B_R3B4B clk a[0] a[1] a[2] a[3] a[4] a[5] a[6] a[7] a[8] vss vdd q[0] q[1] q[2] q[3] q[4] q[5] q[6] q[7] q[8] q[9] q[10] q[11] q[12] q[13] q[14] q[15] q[16] q[17] q[18] q[19] q[20] q[21] q[22] q[23] q[24] q[25] q[26] q[27] q[28] q[29] q[30] q[31] d[0] d[1] d[2] d[3] d[4] d[5] d[6] d[7] d[8] d[9] d[10] d[11] d[12] d[13] d[14] d[15] d[16] d[17] d[18] d[19] d[20] d[21] d[22] d[23] d[24] d[25] d[26] d[27] d[28] d[29] d[30] d[31] we[0] we[1] we[2] we[3]
Xcolumnblock vss vdd columnclk precharge_n we_en wl[0] wl[1] wl[2] wl[3] wl[4] wl[5] wl[6] wl[7] wl[8] wl[9] wl[10] wl[11] wl[12] wl[13] wl[14] wl[15] wl[16] wl[17] wl[18] wl[19] wl[20] wl[21] wl[22] wl[23] wl[24] wl[25] wl[26] wl[27] wl[28] wl[29] wl[30] wl[31] wl[32] wl[33] wl[34] wl[35] wl[36] wl[37] wl[38] wl[39] wl[40] wl[41] wl[42] wl[43] wl[44] wl[45] wl[46] wl[47] wl[48] wl[49] wl[50] wl[51] wl[52] wl[53] wl[54] wl[55] wl[56] wl[57] wl[58] wl[59] wl[60] wl[61] wl[62] wl[63] wl[64] wl[65] wl[66] wl[67] wl[68] wl[69] wl[70] wl[71] wl[72] wl[73] wl[74] wl[75] wl[76] wl[77] wl[78] wl[79] wl[80] wl[81] wl[82] wl[83] wl[84] wl[85] wl[86] wl[87] wl[88] wl[89] wl[90] wl[91] wl[92] wl[93] wl[94] wl[95] wl[96] wl[97] wl[98] wl[99] wl[100] wl[101] wl[102] wl[103] wl[104] wl[105] wl[106] wl[107] wl[108] wl[109] wl[110] wl[111] wl[112] wl[113] wl[114] wl[115] wl[116] wl[117] wl[118] wl[119] wl[120] wl[121] wl[122] wl[123] wl[124] wl[125] wl[126] wl[127] mux[0] mux[1] mux[2] mux[3] we[0] q[0] d[0] q[1] d[1] q[2] d[2] q[3] d[3] q[4] d[4] q[5] d[5] q[6] d[6] q[7] d[7] we[1] q[8] d[8] q[9] d[9] q[10] d[10] q[11] d[11] q[12] d[12] q[13] d[13] q[14] d[14] q[15] d[15] we[2] q[16] d[16] q[17] d[17] q[18] d[18] q[19] d[19] q[20] d[20] q[21] d[21] q[22] d[22] q[23] d[23] we[3] q[24] d[24] q[25] d[25] q[26] d[26] q[27] d[27] q[28] d[28] q[29] d[29] q[30] d[30] q[31] d[31] SP6T1ColumnBlock_COL128R_CP8B_CM4MN26L580W1R_PC26L100W_4WE
Xwldrivercol vss vdd wl[0] wl_n[0] wl[1] wl_n[1] wl[2] wl_n[2] wl[3] wl_n[3] wl[4] wl_n[4] wl[5] wl_n[5] wl[6] wl_n[6] wl[7] wl_n[7] wl[8] wl_n[8] wl[9] wl_n[9] wl[10] wl_n[10] wl[11] wl_n[11] wl[12] wl_n[12] wl[13] wl_n[13] wl[14] wl_n[14] wl[15] wl_n[15] wl[16] wl_n[16] wl[17] wl_n[17] wl[18] wl_n[18] wl[19] wl_n[19] wl[20] wl_n[20] wl[21] wl_n[21] wl[22] wl_n[22] wl[23] wl_n[23] wl[24] wl_n[24] wl[25] wl_n[25] wl[26] wl_n[26] wl[27] wl_n[27] wl[28] wl_n[28] wl[29] wl_n[29] wl[30] wl_n[30] wl[31] wl_n[31] wl[32] wl_n[32] wl[33] wl_n[33] wl[34] wl_n[34] wl[35] wl_n[35] wl[36] wl_n[36] wl[37] wl_n[37] wl[38] wl_n[38] wl[39] wl_n[39] wl[40] wl_n[40] wl[41] wl_n[41] wl[42] wl_n[42] wl[43] wl_n[43] wl[44] wl_n[44] wl[45] wl_n[45] wl[46] wl_n[46] wl[47] wl_n[47] wl[48] wl_n[48] wl[49] wl_n[49] wl[50] wl_n[50] wl[51] wl_n[51] wl[52] wl_n[52] wl[53] wl_n[53] wl[54] wl_n[54] wl[55] wl_n[55] wl[56] wl_n[56] wl[57] wl_n[57] wl[58] wl_n[58] wl[59] wl_n[59] wl[60] wl_n[60] wl[61] wl_n[61] wl[62] wl_n[62] wl[63] wl_n[63] wl[64] wl_n[64] wl[65] wl_n[65] wl[66] wl_n[66] wl[67] wl_n[67] wl[68] wl_n[68] wl[69] wl_n[69] wl[70] wl_n[70] wl[71] wl_n[71] wl[72] wl_n[72] wl[73] wl_n[73] wl[74] wl_n[74] wl[75] wl_n[75] wl[76] wl_n[76] wl[77] wl_n[77] wl[78] wl_n[78] wl[79] wl_n[79] wl[80] wl_n[80] wl[81] wl_n[81] wl[82] wl_n[82] wl[83] wl_n[83] wl[84] wl_n[84] wl[85] wl_n[85] wl[86] wl_n[86] wl[87] wl_n[87] wl[88] wl_n[88] wl[89] wl_n[89] wl[90] wl_n[90] wl[91] wl_n[91] wl[92] wl_n[92] wl[93] wl_n[93] wl[94] wl_n[94] wl[95] wl_n[95] wl[96] wl_n[96] wl[97] wl_n[97] wl[98] wl_n[98] wl[99] wl_n[99] wl[100] wl_n[100] wl[101] wl_n[101] wl[102] wl_n[102] wl[103] wl_n[103] wl[104] wl_n[104] wl[105] wl_n[105] wl[106] wl_n[106] wl[107] wl_n[107] wl[108] wl_n[108] wl[109] wl_n[109] wl[110] wl_n[110] wl[111] wl_n[111] wl[112] wl_n[112] wl[113] wl_n[113] wl[114] wl_n[114] wl[115] wl_n[115] wl[116] wl_n[116] wl[117] wl_n[117] wl[118] wl_n[118] wl[119] wl_n[119] wl[120] wl_n[120] wl[121] wl_n[121] wl[122] wl_n[122] wl[123] wl_n[123] wl[124] wl_n[124] wl[125] wl_n[125] wl[126] wl_n[126] wl[127] wl_n[127] SP6T1WLDriverCol_128RN26L400WP26L800W
Xclkgen vss vdd clk wl_en decodeclk columnclk precharge_n we_en SP6T1ClockGen_4S11341D1R
Xrowperiph vss vdd a[0] a[1] a[2] a[3] a[4] a[5] a[6] a[7] a[8] wl_n[0] wl_n[1] wl_n[2] wl_n[3] wl_n[4] wl_n[5] wl_n[6] wl_n[7] wl_n[8] wl_n[9] wl_n[10] wl_n[11] wl_n[12] wl_n[13] wl_n[14] wl_n[15] wl_n[16] wl_n[17] wl_n[18] wl_n[19] wl_n[20] wl_n[21] wl_n[22] wl_n[23] wl_n[24] wl_n[25] wl_n[26] wl_n[27] wl_n[28] wl_n[29] wl_n[30] wl_n[31] wl_n[32] wl_n[33] wl_n[34] wl_n[35] wl_n[36] wl_n[37] wl_n[38] wl_n[39] wl_n[40] wl_n[41] wl_n[42] wl_n[43] wl_n[44] wl_n[45] wl_n[46] wl_n[47] wl_n[48] wl_n[49] wl_n[50] wl_n[51] wl_n[52] wl_n[53] wl_n[54] wl_n[55] wl_n[56] wl_n[57] wl_n[58] wl_n[59] wl_n[60] wl_n[61] wl_n[62] wl_n[63] wl_n[64] wl_n[65] wl_n[66] wl_n[67] wl_n[68] wl_n[69] wl_n[70] wl_n[71] wl_n[72] wl_n[73] wl_n[74] wl_n[75] wl_n[76] wl_n[77] wl_n[78] wl_n[79] wl_n[80] wl_n[81] wl_n[82] wl_n[83] wl_n[84] wl_n[85] wl_n[86] wl_n[87] wl_n[88] wl_n[89] wl_n[90] wl_n[91] wl_n[92] wl_n[93] wl_n[94] wl_n[95] wl_n[96] wl_n[97] wl_n[98] wl_n[99] wl_n[100] wl_n[101] wl_n[102] wl_n[103] wl_n[104] wl_n[105] wl_n[106] wl_n[107] wl_n[108] wl_n[109] wl_n[110] wl_n[111] wl_n[112] wl_n[113] wl_n[114] wl_n[115] wl_n[116] wl_n[117] wl_n[118] wl_n[119] wl_n[120] wl_n[121] wl_n[122] wl_n[123] wl_n[124] wl_n[125] wl_n[126] wl_n[127] decodeclk wl_en mux[0] mux[1] mux[2] mux[3] SP6T1RowPeriph_PD3B4B_LD2B2R
.ends SP6T1Block_512x32_4we_C2B_R3B4B

.subckt SP6T1TimingIn_9SF vss vdd sr_in sr_out sr_shift sr_latch i[8] i[7] i[6] i[5] i[4] i[3] i[2] i[1] i[0]
Xshiftff[8] vdd vss sr_in sr_shift i_s[8] dff_x1
Xshiftff[7] vdd vss i_s[8] sr_shift i_s[7] dff_x1
Xshiftff[6] vdd vss i_s[7] sr_shift i_s[6] dff_x1
Xshiftff[5] vdd vss i_s[6] sr_shift i_s[5] dff_x1
Xshiftff[4] vdd vss i_s[5] sr_shift i_s[4] dff_x1
Xshiftff[3] vdd vss i_s[4] sr_shift i_s[3] dff_x1
Xshiftff[2] vdd vss i_s[3] sr_shift i_s[2] dff_x1
Xshiftff[1] vdd vss i_s[2] sr_shift i_s[1] dff_x1
Xshiftff[0] vdd vss i_s[1] sr_shift sr_out dff_x1
Xlatchff[8] vdd vss i_s[8] sr_latch i[8] dff_x1
Xlatchff[7] vdd vss i_s[7] sr_latch i[7] dff_x1
Xlatchff[6] vdd vss i_s[6] sr_latch i[6] dff_x1
Xlatchff[5] vdd vss i_s[5] sr_latch i[5] dff_x1
Xlatchff[4] vdd vss i_s[4] sr_latch i[4] dff_x1
Xlatchff[3] vdd vss i_s[3] sr_latch i[3] dff_x1
Xlatchff[2] vdd vss i_s[2] sr_latch i[2] dff_x1
Xlatchff[1] vdd vss i_s[1] sr_latch i[1] dff_x1
Xlatchff[0] vdd vss sr_out sr_latch i[0] dff_x1
.ends SP6T1TimingIn_9SF

.subckt mux2_x1 vdd vss i0 i1 cmd q
Xcmd_inv_nmos cmd_n cmd vss vss sg13_lv_nmos l=1.3e-07 w=7.8e-07
Xcmd_inv_pmos cmd_n cmd vdd vdd sg13_lv_pmos l=1.3e-07 w=7.8e-07
Xi0_nmos vss i0 _net0 vss sg13_lv_nmos l=1.3e-07 w=7.8e-07
Xi0_pmos vdd i0 _net1 vdd sg13_lv_pmos l=1.3e-07 w=7.8e-07
Xcmd_n_npass _net0 cmd_n _q_n vss sg13_lv_nmos l=1.3e-07 w=7.8e-07
Xcmd_ppass _net1 cmd _q_n vdd sg13_lv_pmos l=1.3e-07 w=7.8e-07
Xcmd_npass _q_n cmd _net2 vss sg13_lv_nmos l=1.3e-07 w=7.8e-07
Xcmd_n_ppass _q_n cmd_n _net3 vdd sg13_lv_pmos l=1.3e-07 w=7.8e-07
Xi1_nmos _net2 i1 vss vss sg13_lv_nmos l=1.3e-07 w=7.8e-07
Xi1_pmos _net3 i1 vdd vdd sg13_lv_pmos l=1.3e-07 w=7.8e-07
Xq_n_inv_nmos vss _q_n q vss sg13_lv_nmos l=1.3e-07 w=1.07e-06
Xq_n_inv_pmos vdd _q_n q vdd sg13_lv_pmos l=1.3e-07 w=1.06e-06
.ends mux2_x1

.subckt SP6T1TimingOut_2SL vss vdd sr_in sr_out sr_shift sr_latch l2s o[0] o[1]
Xshiftff[0] vdd vss o_m[0] sr_shift o_s[0] dff_x1
Xshiftff[1] vdd vss o_m[1] sr_shift sr_out dff_x1
Xlatchff[0] vdd vss o[0] sr_latch o_l[0] dff_x1
Xlatchff[1] vdd vss o[1] sr_latch o_l[1] dff_x1
Xmux[0] vdd vss sr_in o_l[0] l2s o_m[0] mux2_x1
Xmux[1] vdd vss o_s[0] o_l[1] l2s o_m[1] mux2_x1
.ends SP6T1TimingOut_2SL

.subckt SP6T1TimingIn_9SL vss vdd sr_in sr_out sr_shift sr_latch i[0] i[1] i[2] i[3] i[4] i[5] i[6] i[7] i[8]
Xshiftff[0] vdd vss sr_in sr_shift i_s[0] dff_x1
Xshiftff[1] vdd vss i_s[0] sr_shift i_s[1] dff_x1
Xshiftff[2] vdd vss i_s[1] sr_shift i_s[2] dff_x1
Xshiftff[3] vdd vss i_s[2] sr_shift i_s[3] dff_x1
Xshiftff[4] vdd vss i_s[3] sr_shift i_s[4] dff_x1
Xshiftff[5] vdd vss i_s[4] sr_shift i_s[5] dff_x1
Xshiftff[6] vdd vss i_s[5] sr_shift i_s[6] dff_x1
Xshiftff[7] vdd vss i_s[6] sr_shift i_s[7] dff_x1
Xshiftff[8] vdd vss i_s[7] sr_shift sr_out dff_x1
Xlatchff[0] vdd vss i_s[0] sr_latch i[0] dff_x1
Xlatchff[1] vdd vss i_s[1] sr_latch i[1] dff_x1
Xlatchff[2] vdd vss i_s[2] sr_latch i[2] dff_x1
Xlatchff[3] vdd vss i_s[3] sr_latch i[3] dff_x1
Xlatchff[4] vdd vss i_s[4] sr_latch i[4] dff_x1
Xlatchff[5] vdd vss i_s[5] sr_latch i[5] dff_x1
Xlatchff[6] vdd vss i_s[6] sr_latch i[6] dff_x1
Xlatchff[7] vdd vss i_s[7] sr_latch i[7] dff_x1
Xlatchff[8] vdd vss sr_out sr_latch i[8] dff_x1
.ends SP6T1TimingIn_9SL

.subckt SP6T1TimingOut_8SL vss vdd sr_in sr_out sr_shift sr_latch l2s o[0] o[1] o[2] o[3] o[4] o[5] o[6] o[7]
Xshiftff[0] vdd vss o_m[0] sr_shift o_s[0] dff_x1
Xshiftff[1] vdd vss o_m[1] sr_shift o_s[1] dff_x1
Xshiftff[2] vdd vss o_m[2] sr_shift o_s[2] dff_x1
Xshiftff[3] vdd vss o_m[3] sr_shift o_s[3] dff_x1
Xshiftff[4] vdd vss o_m[4] sr_shift o_s[4] dff_x1
Xshiftff[5] vdd vss o_m[5] sr_shift o_s[5] dff_x1
Xshiftff[6] vdd vss o_m[6] sr_shift o_s[6] dff_x1
Xshiftff[7] vdd vss o_m[7] sr_shift sr_out dff_x1
Xlatchff[0] vdd vss o[0] sr_latch o_l[0] dff_x1
Xlatchff[1] vdd vss o[1] sr_latch o_l[1] dff_x1
Xlatchff[2] vdd vss o[2] sr_latch o_l[2] dff_x1
Xlatchff[3] vdd vss o[3] sr_latch o_l[3] dff_x1
Xlatchff[4] vdd vss o[4] sr_latch o_l[4] dff_x1
Xlatchff[5] vdd vss o[5] sr_latch o_l[5] dff_x1
Xlatchff[6] vdd vss o[6] sr_latch o_l[6] dff_x1
Xlatchff[7] vdd vss o[7] sr_latch o_l[7] dff_x1
Xmux[0] vdd vss sr_in o_l[0] l2s o_m[0] mux2_x1
Xmux[1] vdd vss o_s[0] o_l[1] l2s o_m[1] mux2_x1
Xmux[2] vdd vss o_s[1] o_l[2] l2s o_m[2] mux2_x1
Xmux[3] vdd vss o_s[2] o_l[3] l2s o_m[3] mux2_x1
Xmux[4] vdd vss o_s[3] o_l[4] l2s o_m[4] mux2_x1
Xmux[5] vdd vss o_s[4] o_l[5] l2s o_m[5] mux2_x1
Xmux[6] vdd vss o_s[5] o_l[6] l2s o_m[6] mux2_x1
Xmux[7] vdd vss o_s[6] o_l[7] l2s o_m[7] mux2_x1
.ends SP6T1TimingOut_8SL

.subckt diode_w1 vdd vss i
.ends diode_w1

.subckt tie_w2 vdd vss
.ends tie_w2

.subckt SP6T1Block_512x32_4we_C2B_R3B4B_Test vss vdd_block vdd_periph clk in_shift in_latch in_srin in_srout out_shift out_latch out_l2s out_srin out_srout
Xblock clk a[0] a[1] a[2] a[3] a[4] a[5] a[6] a[7] a[8] vss vdd_block q[0] q[1] q[2] q[3] q[4] q[5] q[6] q[7] q[8] q[9] q[10] q[11] q[12] q[13] q[14] q[15] q[16] q[17] q[18] q[19] q[20] q[21] q[22] q[23] q[24] q[25] q[26] q[27] q[28] q[29] q[30] q[31] d[0] d[1] d[2] d[3] d[4] d[5] d[6] d[7] d[8] d[9] d[10] d[11] d[12] d[13] d[14] d[15] d[16] d[17] d[18] d[19] d[20] d[21] d[22] d[23] d[24] d[25] d[26] d[27] d[28] d[29] d[30] d[31] we[0] we[1] we[2] we[3] SP6T1Block_512x32_4we_C2B_R3B4B
Xasr vss vdd_periph in_srin in_srconn[0] in_shift in_latch a[8] a[7] a[6] a[5] a[4] a[3] a[2] a[1] a[0] SP6T1TimingIn_9SF
Xclksr vss vdd_periph out_srin out_srconn[0] out_shift clk out_l2s in_latch out_latch SP6T1TimingOut_2SL
Xdwesr[0] vss vdd_periph in_srconn[0] in_srconn[1] in_shift in_latch d[0] d[1] d[2] d[3] d[4] d[5] d[6] d[7] we[0] SP6T1TimingIn_9SL
Xdwesr[1] vss vdd_periph in_srconn[1] in_srconn[2] in_shift in_latch d[8] d[9] d[10] d[11] d[12] d[13] d[14] d[15] we[1] SP6T1TimingIn_9SL
Xdwesr[2] vss vdd_periph in_srconn[2] in_srconn[3] in_shift in_latch d[16] d[17] d[18] d[19] d[20] d[21] d[22] d[23] we[2] SP6T1TimingIn_9SL
Xdwesr[3] vss vdd_periph in_srconn[3] in_srout in_shift in_latch d[24] d[25] d[26] d[27] d[28] d[29] d[30] d[31] we[3] SP6T1TimingIn_9SL
Xqsr[0] vss vdd_periph out_srconn[0] out_srconn[1] out_shift out_latch out_l2s q[0] q[1] q[2] q[3] q[4] q[5] q[6] q[7] SP6T1TimingOut_8SL
Xqsr[1] vss vdd_periph out_srconn[1] out_srconn[2] out_shift out_latch out_l2s q[8] q[9] q[10] q[11] q[12] q[13] q[14] q[15] SP6T1TimingOut_8SL
Xqsr[2] vss vdd_periph out_srconn[2] out_srconn[3] out_shift out_latch out_l2s q[16] q[17] q[18] q[19] q[20] q[21] q[22] q[23] SP6T1TimingOut_8SL
Xqsr[3] vss vdd_periph out_srconn[3] out_srout out_shift out_latch out_l2s q[24] q[25] q[26] q[27] q[28] q[29] q[30] q[31] SP6T1TimingOut_8SL
Xinsrin_antdio vdd_periph vss in_srin diode_w1
Xinshift_antdio vdd_periph vss in_shift diode_w1
Xinlatch_antdio vdd_periph vss in_latch diode_w1
Xfill[0] vdd_periph vss tie_w2
Xfill[1] vdd_periph vss tie_w2
Xoutlatch_antdio vdd_periph vss out_latch diode_w1
Xoutshift_antdio vdd_periph vss out_shift diode_w1
Xoutsrin_antdio vdd_periph vss out_srin diode_w1
Xoutl2s_antdio vdd_periph vss out_l2s diode_w1
Xclk_antdio vdd_periph vss clk diode_w1
Xfill[2] vdd_periph vss tie_w2
Xfill[3] vdd_periph vss tie_w2
.ends SP6T1Block_512x32_4we_C2B_R3B4B_Test

.subckt PadFrame_SP01 PAD0x0 PAD0x1 PAD0x2 PAD0x3 PAD0x4 PAD0x5 PAD0x6 PAD0x7 PAD0x8 PAD0x9 PAD1x0 PAD1x1 PAD1x2 PAD1x3 PAD1x4 PAD1x5 PAD1x6 PAD1x7 PAD1x8 PAD1x9
XPAD0x0 PAD0x0 BondPad
XPAD0x1 PAD0x1 BondPad
XPAD0x2 PAD0x2 BondPad
XPAD0x3 PAD0x3 BondPad
XPAD0x4 PAD0x4 BondPad
XPAD0x5 PAD0x5 BondPad
XPAD0x6 PAD0x6 BondPad
XPAD0x7 PAD0x7 BondPad
XPAD0x8 PAD0x8 BondPad
XPAD0x9 PAD0x9 BondPad
XPAD1x0 PAD1x0 BondPad
XPAD1x1 PAD1x1 BondPad
XPAD1x2 PAD1x2 BondPad
XPAD1x3 PAD1x3 BondPad
XPAD1x4 PAD1x4 BondPad
XPAD1x5 PAD1x5 BondPad
XPAD1x6 PAD1x6 BondPad
XPAD1x7 PAD1x7 BondPad
XPAD1x8 PAD1x8 BondPad
XPAD1x9 PAD1x9 BondPad
.ends PadFrame_SP01

.subckt SP01 vss vdd_periph vdd_block in_srout out_srout clk out_latch out_shift out_l2s out_srin in_shift in_srin in_latch
Xtestblock vss vdd_block vdd_periph clk in_shift in_latch in_srin in_srout out_shift out_latch out_l2s out_srin out_srout SP6T1Block_512x32_4we_C2B_R3B4B_Test
Xpadframe vdd_block vss clk out_shift out_srin in_srin in_latch noconn noconn noconn vdd_periph in_srout out_srout out_latch out_l2s in_shift noconn noconn noconn noconn PadFrame_SP01
.ends SP01

.subckt sp6t1_io clk in_srin in_latch in_shift out_srin out_latch out_shift out_l2s in_srout out_srout vdd_block
Xmem vss vdd_block_int vdd clk_int in_shift_int in_latch_int in_srin_int in_srout_int out_shift_int out_latch_int out_l2s_int out_srin_int out_srout_int SP6T1Block_512x32_4we_C2B_R3B4B_Test
Xclk_bp clk BondPad
Xclk_io clk clk_int sg13g2_IOPadIn
Xin_srin_bp in_srin BondPad
Xin_srin_io in_srin in_srin_int sg13g2_IOPadIn
Xin_latch_bp in_latch BondPad
Xin_latch_io in_latch in_latch_int sg13g2_IOPadIn
Xin_shift_bp in_shift BondPad
Xin_shift_io in_shift in_shift_int sg13g2_IOPadIn
Xout_srin_bp out_srin BondPad
Xout_srin_io out_srin out_srin_int sg13g2_IOPadIn
Xout_latch_bp out_latch BondPad
Xout_latch_io out_latch out_latch_int sg13g2_IOPadIn
Xout_shift_bp out_shift BondPad
Xout_shift_io out_shift out_shift_int sg13g2_IOPadIn
Xout_l2s_bp out_l2s BondPad
Xout_l2s_io out_l2s out_l2s_int sg13g2_IOPadIn
Xin_srout_bp in_srout BondPad
Xin_srout_io in_srout in_srout_int sg13g2_IOPadOut30mA
Xout_srout_bp out_srout BondPad
Xout_srout_io out_srout out_srout_int sg13g2_IOPadOut30mA
Xvdd_block_bp vdd_block BondPad
Xvdd_block_io vdd_block vdd_block_int sg13g2_IOPadAnalog
Xiofill0  sg13g2_Filler4000
Xiofill1  sg13g2_Filler4000
Xiofill2  sg13g2_Filler4000
Xiofill3  sg13g2_Filler4000
Xiofill4  sg13g2_Filler4000
Xiofill5  sg13g2_Filler4000
Xiofill6  sg13g2_Filler4000
Xiofill7  sg13g2_Filler4000
Xiofill8  sg13g2_Filler4000
Xiofill9  sg13g2_Filler4000
.ends sp6t1_io

.subckt SP6T2Cell vss substrate vdd nwell wl bl bl_n
Xpu1 vdd bit_n bit nwell sg13_lv_pmos l=1.3e-07 w=5.5e-07
Xpd1 bit bit_n vss substrate sg13_lv_nmos l=1.3e-07 w=5.5e-07
Xpu2 vdd bit bit_n nwell sg13_lv_pmos l=1.3e-07 w=5.5e-07
Xpd2 bit_n bit vss substrate sg13_lv_nmos l=1.3e-07 w=5.5e-07
Xpg1 bit wl bl substrate sg13_lv_nmos l=1.3e-07 w=3e-07
Xpg2 bit_n wl bl_n substrate sg13_lv_nmos l=1.3e-07 w=3e-07
.ends SP6T2Cell

.subckt SP6T2Array_2X1 vss substrate vdd nwell wl[0] wl[1] bl[0] bl_n[0]
Xinst0x0 vss substrate vdd nwell wl[0] bl[0] bl_n[0] SP6T2Cell
Xinst1x0 vss substrate vdd nwell wl[1] bl[0] bl_n[0] SP6T2Cell
.ends SP6T2Array_2X1

.subckt SP6T2Array_2X2 vss substrate vdd nwell wl[0] wl[1] bl[0] bl_n[0] bl[1] bl_n[1]
Xinst0x0 vss substrate vdd nwell wl[0] wl[1] bl[0] bl_n[0] SP6T2Array_2X1
Xinst0x1 vss substrate vdd nwell wl[0] wl[1] bl[1] bl_n[1] SP6T2Array_2X1
.ends SP6T2Array_2X2

.subckt SP6T2Array_4X2 vss substrate vdd nwell wl[0] wl[1] wl[2] wl[3] bl[0] bl_n[0] bl[1] bl_n[1]
Xinst0x0 vss substrate vdd nwell wl[0] wl[1] bl[0] bl_n[0] bl[1] bl_n[1] SP6T2Array_2X2
Xinst1x0 vss substrate vdd nwell wl[2] wl[3] bl[0] bl_n[0] bl[1] bl_n[1] SP6T2Array_2X2
.ends SP6T2Array_4X2

.subckt SP6T2Array_4X4 vss substrate vdd nwell wl[0] wl[1] wl[2] wl[3] bl[0] bl_n[0] bl[1] bl_n[1] bl[2] bl_n[2] bl[3] bl_n[3]
Xinst0x0 vss substrate vdd nwell wl[0] wl[1] wl[2] wl[3] bl[0] bl_n[0] bl[1] bl_n[1] SP6T2Array_4X2
Xinst0x1 vss substrate vdd nwell wl[0] wl[1] wl[2] wl[3] bl[2] bl_n[2] bl[3] bl_n[3] SP6T2Array_4X2
.ends SP6T2Array_4X4

.subckt SP6T2Array_8X4 vss substrate vdd nwell wl[0] wl[1] wl[2] wl[3] wl[4] wl[5] wl[6] wl[7] bl[0] bl_n[0] bl[1] bl_n[1] bl[2] bl_n[2] bl[3] bl_n[3]
Xinst0x0 vss substrate vdd nwell wl[0] wl[1] wl[2] wl[3] bl[0] bl_n[0] bl[1] bl_n[1] bl[2] bl_n[2] bl[3] bl_n[3] SP6T2Array_4X4
Xinst1x0 vss substrate vdd nwell wl[4] wl[5] wl[6] wl[7] bl[0] bl_n[0] bl[1] bl_n[1] bl[2] bl_n[2] bl[3] bl_n[3] SP6T2Array_4X4
.ends SP6T2Array_8X4

.subckt SP6T2Array_8X8 vss substrate vdd nwell wl[0] wl[1] wl[2] wl[3] wl[4] wl[5] wl[6] wl[7] bl[0] bl_n[0] bl[1] bl_n[1] bl[2] bl_n[2] bl[3] bl_n[3] bl[4] bl_n[4] bl[5] bl_n[5] bl[6] bl_n[6] bl[7] bl_n[7]
Xinst0x0 vss substrate vdd nwell wl[0] wl[1] wl[2] wl[3] wl[4] wl[5] wl[6] wl[7] bl[0] bl_n[0] bl[1] bl_n[1] bl[2] bl_n[2] bl[3] bl_n[3] SP6T2Array_8X4
Xinst0x1 vss substrate vdd nwell wl[0] wl[1] wl[2] wl[3] wl[4] wl[5] wl[6] wl[7] bl[4] bl_n[4] bl[5] bl_n[5] bl[6] bl_n[6] bl[7] bl_n[7] SP6T2Array_8X4
.ends SP6T2Array_8X8

.subckt SP6T2Array_16X8 vss substrate vdd nwell wl[0] wl[1] wl[2] wl[3] wl[4] wl[5] wl[6] wl[7] wl[8] wl[9] wl[10] wl[11] wl[12] wl[13] wl[14] wl[15] bl[0] bl_n[0] bl[1] bl_n[1] bl[2] bl_n[2] bl[3] bl_n[3] bl[4] bl_n[4] bl[5] bl_n[5] bl[6] bl_n[6] bl[7] bl_n[7]
Xinst0x0 vss substrate vdd nwell wl[0] wl[1] wl[2] wl[3] wl[4] wl[5] wl[6] wl[7] bl[0] bl_n[0] bl[1] bl_n[1] bl[2] bl_n[2] bl[3] bl_n[3] bl[4] bl_n[4] bl[5] bl_n[5] bl[6] bl_n[6] bl[7] bl_n[7] SP6T2Array_8X8
Xinst1x0 vss substrate vdd nwell wl[8] wl[9] wl[10] wl[11] wl[12] wl[13] wl[14] wl[15] bl[0] bl_n[0] bl[1] bl_n[1] bl[2] bl_n[2] bl[3] bl_n[3] bl[4] bl_n[4] bl[5] bl_n[5] bl[6] bl_n[6] bl[7] bl_n[7] SP6T2Array_8X8
.ends SP6T2Array_16X8

.subckt SP6T2Array_16X16 vss substrate vdd nwell wl[0] wl[1] wl[2] wl[3] wl[4] wl[5] wl[6] wl[7] wl[8] wl[9] wl[10] wl[11] wl[12] wl[13] wl[14] wl[15] bl[0] bl_n[0] bl[1] bl_n[1] bl[2] bl_n[2] bl[3] bl_n[3] bl[4] bl_n[4] bl[5] bl_n[5] bl[6] bl_n[6] bl[7] bl_n[7] bl[8] bl_n[8] bl[9] bl_n[9] bl[10] bl_n[10] bl[11] bl_n[11] bl[12] bl_n[12] bl[13] bl_n[13] bl[14] bl_n[14] bl[15] bl_n[15]
Xinst0x0 vss substrate vdd nwell wl[0] wl[1] wl[2] wl[3] wl[4] wl[5] wl[6] wl[7] wl[8] wl[9] wl[10] wl[11] wl[12] wl[13] wl[14] wl[15] bl[0] bl_n[0] bl[1] bl_n[1] bl[2] bl_n[2] bl[3] bl_n[3] bl[4] bl_n[4] bl[5] bl_n[5] bl[6] bl_n[6] bl[7] bl_n[7] SP6T2Array_16X8
Xinst0x1 vss substrate vdd nwell wl[0] wl[1] wl[2] wl[3] wl[4] wl[5] wl[6] wl[7] wl[8] wl[9] wl[10] wl[11] wl[12] wl[13] wl[14] wl[15] bl[8] bl_n[8] bl[9] bl_n[9] bl[10] bl_n[10] bl[11] bl_n[11] bl[12] bl_n[12] bl[13] bl_n[13] bl[14] bl_n[14] bl[15] bl_n[15] SP6T2Array_16X8
.ends SP6T2Array_16X16

.subckt SP6T2Array_16X32 vss substrate vdd nwell wl[0] wl[1] wl[2] wl[3] wl[4] wl[5] wl[6] wl[7] wl[8] wl[9] wl[10] wl[11] wl[12] wl[13] wl[14] wl[15] bl[0] bl_n[0] bl[1] bl_n[1] bl[2] bl_n[2] bl[3] bl_n[3] bl[4] bl_n[4] bl[5] bl_n[5] bl[6] bl_n[6] bl[7] bl_n[7] bl[8] bl_n[8] bl[9] bl_n[9] bl[10] bl_n[10] bl[11] bl_n[11] bl[12] bl_n[12] bl[13] bl_n[13] bl[14] bl_n[14] bl[15] bl_n[15] bl[16] bl_n[16] bl[17] bl_n[17] bl[18] bl_n[18] bl[19] bl_n[19] bl[20] bl_n[20] bl[21] bl_n[21] bl[22] bl_n[22] bl[23] bl_n[23] bl[24] bl_n[24] bl[25] bl_n[25] bl[26] bl_n[26] bl[27] bl_n[27] bl[28] bl_n[28] bl[29] bl_n[29] bl[30] bl_n[30] bl[31] bl_n[31]
Xinst0x0 vss substrate vdd nwell wl[0] wl[1] wl[2] wl[3] wl[4] wl[5] wl[6] wl[7] wl[8] wl[9] wl[10] wl[11] wl[12] wl[13] wl[14] wl[15] bl[0] bl_n[0] bl[1] bl_n[1] bl[2] bl_n[2] bl[3] bl_n[3] bl[4] bl_n[4] bl[5] bl_n[5] bl[6] bl_n[6] bl[7] bl_n[7] bl[8] bl_n[8] bl[9] bl_n[9] bl[10] bl_n[10] bl[11] bl_n[11] bl[12] bl_n[12] bl[13] bl_n[13] bl[14] bl_n[14] bl[15] bl_n[15] SP6T2Array_16X16
Xinst0x1 vss substrate vdd nwell wl[0] wl[1] wl[2] wl[3] wl[4] wl[5] wl[6] wl[7] wl[8] wl[9] wl[10] wl[11] wl[12] wl[13] wl[14] wl[15] bl[16] bl_n[16] bl[17] bl_n[17] bl[18] bl_n[18] bl[19] bl_n[19] bl[20] bl_n[20] bl[21] bl_n[21] bl[22] bl_n[22] bl[23] bl_n[23] bl[24] bl_n[24] bl[25] bl_n[25] bl[26] bl_n[26] bl[27] bl_n[27] bl[28] bl_n[28] bl[29] bl_n[29] bl[30] bl_n[30] bl[31] bl_n[31] SP6T2Array_16X16
.ends SP6T2Array_16X32

.subckt SP6T2BulkConn vdd vss bl bl_n
.ends SP6T2BulkConn

.subckt SP6T2BulkConnRow_2C vss vdd bl[0] bl_n[0] bl[1] bl_n[1]
Xinst0 vdd vss bl[0] bl_n[0] SP6T2BulkConn
Xinst1 vdd vss bl[1] bl_n[1] SP6T2BulkConn
.ends SP6T2BulkConnRow_2C

.subckt SP6T2BulkConnRow_4C vss vdd bl[0] bl_n[0] bl[1] bl_n[1] bl[2] bl_n[2] bl[3] bl_n[3]
Xinst0 vss vdd bl[0] bl_n[0] bl[1] bl_n[1] SP6T2BulkConnRow_2C
Xinst1 vss vdd bl[2] bl_n[2] bl[3] bl_n[3] SP6T2BulkConnRow_2C
.ends SP6T2BulkConnRow_4C

.subckt SP6T2BulkConnRow_8C vss vdd bl[0] bl_n[0] bl[1] bl_n[1] bl[2] bl_n[2] bl[3] bl_n[3] bl[4] bl_n[4] bl[5] bl_n[5] bl[6] bl_n[6] bl[7] bl_n[7]
Xinst0 vss vdd bl[0] bl_n[0] bl[1] bl_n[1] bl[2] bl_n[2] bl[3] bl_n[3] SP6T2BulkConnRow_4C
Xinst1 vss vdd bl[4] bl_n[4] bl[5] bl_n[5] bl[6] bl_n[6] bl[7] bl_n[7] SP6T2BulkConnRow_4C
.ends SP6T2BulkConnRow_8C

.subckt SP6T2BulkConnRow_16C vss vdd bl[0] bl_n[0] bl[1] bl_n[1] bl[2] bl_n[2] bl[3] bl_n[3] bl[4] bl_n[4] bl[5] bl_n[5] bl[6] bl_n[6] bl[7] bl_n[7] bl[8] bl_n[8] bl[9] bl_n[9] bl[10] bl_n[10] bl[11] bl_n[11] bl[12] bl_n[12] bl[13] bl_n[13] bl[14] bl_n[14] bl[15] bl_n[15]
Xinst0 vss vdd bl[0] bl_n[0] bl[1] bl_n[1] bl[2] bl_n[2] bl[3] bl_n[3] bl[4] bl_n[4] bl[5] bl_n[5] bl[6] bl_n[6] bl[7] bl_n[7] SP6T2BulkConnRow_8C
Xinst1 vss vdd bl[8] bl_n[8] bl[9] bl_n[9] bl[10] bl_n[10] bl[11] bl_n[11] bl[12] bl_n[12] bl[13] bl_n[13] bl[14] bl_n[14] bl[15] bl_n[15] SP6T2BulkConnRow_8C
.ends SP6T2BulkConnRow_16C

.subckt SP6T2BulkConnRow_32C vss vdd bl[0] bl_n[0] bl[1] bl_n[1] bl[2] bl_n[2] bl[3] bl_n[3] bl[4] bl_n[4] bl[5] bl_n[5] bl[6] bl_n[6] bl[7] bl_n[7] bl[8] bl_n[8] bl[9] bl_n[9] bl[10] bl_n[10] bl[11] bl_n[11] bl[12] bl_n[12] bl[13] bl_n[13] bl[14] bl_n[14] bl[15] bl_n[15] bl[16] bl_n[16] bl[17] bl_n[17] bl[18] bl_n[18] bl[19] bl_n[19] bl[20] bl_n[20] bl[21] bl_n[21] bl[22] bl_n[22] bl[23] bl_n[23] bl[24] bl_n[24] bl[25] bl_n[25] bl[26] bl_n[26] bl[27] bl_n[27] bl[28] bl_n[28] bl[29] bl_n[29] bl[30] bl_n[30] bl[31] bl_n[31]
Xinst0 vss vdd bl[0] bl_n[0] bl[1] bl_n[1] bl[2] bl_n[2] bl[3] bl_n[3] bl[4] bl_n[4] bl[5] bl_n[5] bl[6] bl_n[6] bl[7] bl_n[7] bl[8] bl_n[8] bl[9] bl_n[9] bl[10] bl_n[10] bl[11] bl_n[11] bl[12] bl_n[12] bl[13] bl_n[13] bl[14] bl_n[14] bl[15] bl_n[15] SP6T2BulkConnRow_16C
Xinst1 vss vdd bl[16] bl_n[16] bl[17] bl_n[17] bl[18] bl_n[18] bl[19] bl_n[19] bl[20] bl_n[20] bl[21] bl_n[21] bl[22] bl_n[22] bl[23] bl_n[23] bl[24] bl_n[24] bl[25] bl_n[25] bl[26] bl_n[26] bl[27] bl_n[27] bl[28] bl_n[28] bl[29] bl_n[29] bl[30] bl_n[30] bl[31] bl_n[31] SP6T2BulkConnRow_16C
.ends SP6T2BulkConnRow_32C

.subckt SP6T2Array_32X32 vss vdd wl[0] wl[1] wl[2] wl[3] wl[4] wl[5] wl[6] wl[7] wl[8] wl[9] wl[10] wl[11] wl[12] wl[13] wl[14] wl[15] wl[16] wl[17] wl[18] wl[19] wl[20] wl[21] wl[22] wl[23] wl[24] wl[25] wl[26] wl[27] wl[28] wl[29] wl[30] wl[31] bl[0] bl_n[0] bl[1] bl_n[1] bl[2] bl_n[2] bl[3] bl_n[3] bl[4] bl_n[4] bl[5] bl_n[5] bl[6] bl_n[6] bl[7] bl_n[7] bl[8] bl_n[8] bl[9] bl_n[9] bl[10] bl_n[10] bl[11] bl_n[11] bl[12] bl_n[12] bl[13] bl_n[13] bl[14] bl_n[14] bl[15] bl_n[15] bl[16] bl_n[16] bl[17] bl_n[17] bl[18] bl_n[18] bl[19] bl_n[19] bl[20] bl_n[20] bl[21] bl_n[21] bl[22] bl_n[22] bl[23] bl_n[23] bl[24] bl_n[24] bl[25] bl_n[25] bl[26] bl_n[26] bl[27] bl_n[27] bl[28] bl_n[28] bl[29] bl_n[29] bl[30] bl_n[30] bl[31] bl_n[31]
Xinst0x0 vss vss vdd vdd wl[0] wl[1] wl[2] wl[3] wl[4] wl[5] wl[6] wl[7] wl[8] wl[9] wl[10] wl[11] wl[12] wl[13] wl[14] wl[15] bl[0] bl_n[0] bl[1] bl_n[1] bl[2] bl_n[2] bl[3] bl_n[3] bl[4] bl_n[4] bl[5] bl_n[5] bl[6] bl_n[6] bl[7] bl_n[7] bl[8] bl_n[8] bl[9] bl_n[9] bl[10] bl_n[10] bl[11] bl_n[11] bl[12] bl_n[12] bl[13] bl_n[13] bl[14] bl_n[14] bl[15] bl_n[15] bl[16] bl_n[16] bl[17] bl_n[17] bl[18] bl_n[18] bl[19] bl_n[19] bl[20] bl_n[20] bl[21] bl_n[21] bl[22] bl_n[22] bl[23] bl_n[23] bl[24] bl_n[24] bl[25] bl_n[25] bl[26] bl_n[26] bl[27] bl_n[27] bl[28] bl_n[28] bl[29] bl_n[29] bl[30] bl_n[30] bl[31] bl_n[31] SP6T2Array_16X32
Xinst1x0 vss vss vdd vdd wl[16] wl[17] wl[18] wl[19] wl[20] wl[21] wl[22] wl[23] wl[24] wl[25] wl[26] wl[27] wl[28] wl[29] wl[30] wl[31] bl[0] bl_n[0] bl[1] bl_n[1] bl[2] bl_n[2] bl[3] bl_n[3] bl[4] bl_n[4] bl[5] bl_n[5] bl[6] bl_n[6] bl[7] bl_n[7] bl[8] bl_n[8] bl[9] bl_n[9] bl[10] bl_n[10] bl[11] bl_n[11] bl[12] bl_n[12] bl[13] bl_n[13] bl[14] bl_n[14] bl[15] bl_n[15] bl[16] bl_n[16] bl[17] bl_n[17] bl[18] bl_n[18] bl[19] bl_n[19] bl[20] bl_n[20] bl[21] bl_n[21] bl[22] bl_n[22] bl[23] bl_n[23] bl[24] bl_n[24] bl[25] bl_n[25] bl[26] bl_n[26] bl[27] bl_n[27] bl[28] bl_n[28] bl[29] bl_n[29] bl[30] bl_n[30] bl[31] bl_n[31] SP6T2Array_16X32
Xbcrow vss vdd bl[0] bl_n[0] bl[1] bl_n[1] bl[2] bl_n[2] bl[3] bl_n[3] bl[4] bl_n[4] bl[5] bl_n[5] bl[6] bl_n[6] bl[7] bl_n[7] bl[8] bl_n[8] bl[9] bl_n[9] bl[10] bl_n[10] bl[11] bl_n[11] bl[12] bl_n[12] bl[13] bl_n[13] bl[14] bl_n[14] bl[15] bl_n[15] bl[16] bl_n[16] bl[17] bl_n[17] bl[18] bl_n[18] bl[19] bl_n[19] bl[20] bl_n[20] bl[21] bl_n[21] bl[22] bl_n[22] bl[23] bl_n[23] bl[24] bl_n[24] bl[25] bl_n[25] bl[26] bl_n[26] bl[27] bl_n[27] bl[28] bl_n[28] bl[29] bl_n[29] bl[30] bl_n[30] bl[31] bl_n[31] SP6T2BulkConnRow_32C
.ends SP6T2Array_32X32

.subckt SP6T2Array_64X32 vss vdd wl[0] wl[1] wl[2] wl[3] wl[4] wl[5] wl[6] wl[7] wl[8] wl[9] wl[10] wl[11] wl[12] wl[13] wl[14] wl[15] wl[16] wl[17] wl[18] wl[19] wl[20] wl[21] wl[22] wl[23] wl[24] wl[25] wl[26] wl[27] wl[28] wl[29] wl[30] wl[31] wl[32] wl[33] wl[34] wl[35] wl[36] wl[37] wl[38] wl[39] wl[40] wl[41] wl[42] wl[43] wl[44] wl[45] wl[46] wl[47] wl[48] wl[49] wl[50] wl[51] wl[52] wl[53] wl[54] wl[55] wl[56] wl[57] wl[58] wl[59] wl[60] wl[61] wl[62] wl[63] bl[0] bl_n[0] bl[1] bl_n[1] bl[2] bl_n[2] bl[3] bl_n[3] bl[4] bl_n[4] bl[5] bl_n[5] bl[6] bl_n[6] bl[7] bl_n[7] bl[8] bl_n[8] bl[9] bl_n[9] bl[10] bl_n[10] bl[11] bl_n[11] bl[12] bl_n[12] bl[13] bl_n[13] bl[14] bl_n[14] bl[15] bl_n[15] bl[16] bl_n[16] bl[17] bl_n[17] bl[18] bl_n[18] bl[19] bl_n[19] bl[20] bl_n[20] bl[21] bl_n[21] bl[22] bl_n[22] bl[23] bl_n[23] bl[24] bl_n[24] bl[25] bl_n[25] bl[26] bl_n[26] bl[27] bl_n[27] bl[28] bl_n[28] bl[29] bl_n[29] bl[30] bl_n[30] bl[31] bl_n[31]
Xinst0x0 vss vdd wl[0] wl[1] wl[2] wl[3] wl[4] wl[5] wl[6] wl[7] wl[8] wl[9] wl[10] wl[11] wl[12] wl[13] wl[14] wl[15] wl[16] wl[17] wl[18] wl[19] wl[20] wl[21] wl[22] wl[23] wl[24] wl[25] wl[26] wl[27] wl[28] wl[29] wl[30] wl[31] bl[0] bl_n[0] bl[1] bl_n[1] bl[2] bl_n[2] bl[3] bl_n[3] bl[4] bl_n[4] bl[5] bl_n[5] bl[6] bl_n[6] bl[7] bl_n[7] bl[8] bl_n[8] bl[9] bl_n[9] bl[10] bl_n[10] bl[11] bl_n[11] bl[12] bl_n[12] bl[13] bl_n[13] bl[14] bl_n[14] bl[15] bl_n[15] bl[16] bl_n[16] bl[17] bl_n[17] bl[18] bl_n[18] bl[19] bl_n[19] bl[20] bl_n[20] bl[21] bl_n[21] bl[22] bl_n[22] bl[23] bl_n[23] bl[24] bl_n[24] bl[25] bl_n[25] bl[26] bl_n[26] bl[27] bl_n[27] bl[28] bl_n[28] bl[29] bl_n[29] bl[30] bl_n[30] bl[31] bl_n[31] SP6T2Array_32X32
Xinst1x0 vss vdd wl[32] wl[33] wl[34] wl[35] wl[36] wl[37] wl[38] wl[39] wl[40] wl[41] wl[42] wl[43] wl[44] wl[45] wl[46] wl[47] wl[48] wl[49] wl[50] wl[51] wl[52] wl[53] wl[54] wl[55] wl[56] wl[57] wl[58] wl[59] wl[60] wl[61] wl[62] wl[63] bl[0] bl_n[0] bl[1] bl_n[1] bl[2] bl_n[2] bl[3] bl_n[3] bl[4] bl_n[4] bl[5] bl_n[5] bl[6] bl_n[6] bl[7] bl_n[7] bl[8] bl_n[8] bl[9] bl_n[9] bl[10] bl_n[10] bl[11] bl_n[11] bl[12] bl_n[12] bl[13] bl_n[13] bl[14] bl_n[14] bl[15] bl_n[15] bl[16] bl_n[16] bl[17] bl_n[17] bl[18] bl_n[18] bl[19] bl_n[19] bl[20] bl_n[20] bl[21] bl_n[21] bl[22] bl_n[22] bl[23] bl_n[23] bl[24] bl_n[24] bl[25] bl_n[25] bl[26] bl_n[26] bl[27] bl_n[27] bl[28] bl_n[28] bl[29] bl_n[29] bl[30] bl_n[30] bl[31] bl_n[31] SP6T2Array_32X32
Xbcrow vss vdd bl[0] bl_n[0] bl[1] bl_n[1] bl[2] bl_n[2] bl[3] bl_n[3] bl[4] bl_n[4] bl[5] bl_n[5] bl[6] bl_n[6] bl[7] bl_n[7] bl[8] bl_n[8] bl[9] bl_n[9] bl[10] bl_n[10] bl[11] bl_n[11] bl[12] bl_n[12] bl[13] bl_n[13] bl[14] bl_n[14] bl[15] bl_n[15] bl[16] bl_n[16] bl[17] bl_n[17] bl[18] bl_n[18] bl[19] bl_n[19] bl[20] bl_n[20] bl[21] bl_n[21] bl[22] bl_n[22] bl[23] bl_n[23] bl[24] bl_n[24] bl[25] bl_n[25] bl[26] bl_n[26] bl[27] bl_n[27] bl[28] bl_n[28] bl[29] bl_n[29] bl[30] bl_n[30] bl[31] bl_n[31] SP6T2BulkConnRow_32C
.ends SP6T2Array_64X32

.subckt SP6T2Array_128X32BC vss vdd wl[0] wl[1] wl[2] wl[3] wl[4] wl[5] wl[6] wl[7] wl[8] wl[9] wl[10] wl[11] wl[12] wl[13] wl[14] wl[15] wl[16] wl[17] wl[18] wl[19] wl[20] wl[21] wl[22] wl[23] wl[24] wl[25] wl[26] wl[27] wl[28] wl[29] wl[30] wl[31] wl[32] wl[33] wl[34] wl[35] wl[36] wl[37] wl[38] wl[39] wl[40] wl[41] wl[42] wl[43] wl[44] wl[45] wl[46] wl[47] wl[48] wl[49] wl[50] wl[51] wl[52] wl[53] wl[54] wl[55] wl[56] wl[57] wl[58] wl[59] wl[60] wl[61] wl[62] wl[63] wl[64] wl[65] wl[66] wl[67] wl[68] wl[69] wl[70] wl[71] wl[72] wl[73] wl[74] wl[75] wl[76] wl[77] wl[78] wl[79] wl[80] wl[81] wl[82] wl[83] wl[84] wl[85] wl[86] wl[87] wl[88] wl[89] wl[90] wl[91] wl[92] wl[93] wl[94] wl[95] wl[96] wl[97] wl[98] wl[99] wl[100] wl[101] wl[102] wl[103] wl[104] wl[105] wl[106] wl[107] wl[108] wl[109] wl[110] wl[111] wl[112] wl[113] wl[114] wl[115] wl[116] wl[117] wl[118] wl[119] wl[120] wl[121] wl[122] wl[123] wl[124] wl[125] wl[126] wl[127] bl[0] bl_n[0] bl[1] bl_n[1] bl[2] bl_n[2] bl[3] bl_n[3] bl[4] bl_n[4] bl[5] bl_n[5] bl[6] bl_n[6] bl[7] bl_n[7] bl[8] bl_n[8] bl[9] bl_n[9] bl[10] bl_n[10] bl[11] bl_n[11] bl[12] bl_n[12] bl[13] bl_n[13] bl[14] bl_n[14] bl[15] bl_n[15] bl[16] bl_n[16] bl[17] bl_n[17] bl[18] bl_n[18] bl[19] bl_n[19] bl[20] bl_n[20] bl[21] bl_n[21] bl[22] bl_n[22] bl[23] bl_n[23] bl[24] bl_n[24] bl[25] bl_n[25] bl[26] bl_n[26] bl[27] bl_n[27] bl[28] bl_n[28] bl[29] bl_n[29] bl[30] bl_n[30] bl[31] bl_n[31]
Xinst0x0 vss vdd wl[0] wl[1] wl[2] wl[3] wl[4] wl[5] wl[6] wl[7] wl[8] wl[9] wl[10] wl[11] wl[12] wl[13] wl[14] wl[15] wl[16] wl[17] wl[18] wl[19] wl[20] wl[21] wl[22] wl[23] wl[24] wl[25] wl[26] wl[27] wl[28] wl[29] wl[30] wl[31] wl[32] wl[33] wl[34] wl[35] wl[36] wl[37] wl[38] wl[39] wl[40] wl[41] wl[42] wl[43] wl[44] wl[45] wl[46] wl[47] wl[48] wl[49] wl[50] wl[51] wl[52] wl[53] wl[54] wl[55] wl[56] wl[57] wl[58] wl[59] wl[60] wl[61] wl[62] wl[63] bl[0] bl_n[0] bl[1] bl_n[1] bl[2] bl_n[2] bl[3] bl_n[3] bl[4] bl_n[4] bl[5] bl_n[5] bl[6] bl_n[6] bl[7] bl_n[7] bl[8] bl_n[8] bl[9] bl_n[9] bl[10] bl_n[10] bl[11] bl_n[11] bl[12] bl_n[12] bl[13] bl_n[13] bl[14] bl_n[14] bl[15] bl_n[15] bl[16] bl_n[16] bl[17] bl_n[17] bl[18] bl_n[18] bl[19] bl_n[19] bl[20] bl_n[20] bl[21] bl_n[21] bl[22] bl_n[22] bl[23] bl_n[23] bl[24] bl_n[24] bl[25] bl_n[25] bl[26] bl_n[26] bl[27] bl_n[27] bl[28] bl_n[28] bl[29] bl_n[29] bl[30] bl_n[30] bl[31] bl_n[31] SP6T2Array_64X32
Xinst1x0 vss vdd wl[64] wl[65] wl[66] wl[67] wl[68] wl[69] wl[70] wl[71] wl[72] wl[73] wl[74] wl[75] wl[76] wl[77] wl[78] wl[79] wl[80] wl[81] wl[82] wl[83] wl[84] wl[85] wl[86] wl[87] wl[88] wl[89] wl[90] wl[91] wl[92] wl[93] wl[94] wl[95] wl[96] wl[97] wl[98] wl[99] wl[100] wl[101] wl[102] wl[103] wl[104] wl[105] wl[106] wl[107] wl[108] wl[109] wl[110] wl[111] wl[112] wl[113] wl[114] wl[115] wl[116] wl[117] wl[118] wl[119] wl[120] wl[121] wl[122] wl[123] wl[124] wl[125] wl[126] wl[127] bl[0] bl_n[0] bl[1] bl_n[1] bl[2] bl_n[2] bl[3] bl_n[3] bl[4] bl_n[4] bl[5] bl_n[5] bl[6] bl_n[6] bl[7] bl_n[7] bl[8] bl_n[8] bl[9] bl_n[9] bl[10] bl_n[10] bl[11] bl_n[11] bl[12] bl_n[12] bl[13] bl_n[13] bl[14] bl_n[14] bl[15] bl_n[15] bl[16] bl_n[16] bl[17] bl_n[17] bl[18] bl_n[18] bl[19] bl_n[19] bl[20] bl_n[20] bl[21] bl_n[21] bl[22] bl_n[22] bl[23] bl_n[23] bl[24] bl_n[24] bl[25] bl_n[25] bl[26] bl_n[26] bl[27] bl_n[27] bl[28] bl_n[28] bl[29] bl_n[29] bl[30] bl_n[30] bl[31] bl_n[31] SP6T2Array_64X32
Xbcrow vss vdd bl[0] bl_n[0] bl[1] bl_n[1] bl[2] bl_n[2] bl[3] bl_n[3] bl[4] bl_n[4] bl[5] bl_n[5] bl[6] bl_n[6] bl[7] bl_n[7] bl[8] bl_n[8] bl[9] bl_n[9] bl[10] bl_n[10] bl[11] bl_n[11] bl[12] bl_n[12] bl[13] bl_n[13] bl[14] bl_n[14] bl[15] bl_n[15] bl[16] bl_n[16] bl[17] bl_n[17] bl[18] bl_n[18] bl[19] bl_n[19] bl[20] bl_n[20] bl[21] bl_n[21] bl[22] bl_n[22] bl[23] bl_n[23] bl[24] bl_n[24] bl[25] bl_n[25] bl[26] bl_n[26] bl[27] bl_n[27] bl[28] bl_n[28] bl[29] bl_n[29] bl[30] bl_n[30] bl[31] bl_n[31] SP6T2BulkConnRow_32C
Xbottombcrow vss vdd bl[0] bl_n[0] bl[1] bl_n[1] bl[2] bl_n[2] bl[3] bl_n[3] bl[4] bl_n[4] bl[5] bl_n[5] bl[6] bl_n[6] bl[7] bl_n[7] bl[8] bl_n[8] bl[9] bl_n[9] bl[10] bl_n[10] bl[11] bl_n[11] bl[12] bl_n[12] bl[13] bl_n[13] bl[14] bl_n[14] bl[15] bl_n[15] bl[16] bl_n[16] bl[17] bl_n[17] bl[18] bl_n[18] bl[19] bl_n[19] bl[20] bl_n[20] bl[21] bl_n[21] bl[22] bl_n[22] bl[23] bl_n[23] bl[24] bl_n[24] bl[25] bl_n[25] bl[26] bl_n[26] bl[27] bl_n[27] bl[28] bl_n[28] bl[29] bl_n[29] bl[30] bl_n[30] bl[31] bl_n[31] SP6T2BulkConnRow_32C
Xtopbcrow vss vdd bl[0] bl_n[0] bl[1] bl_n[1] bl[2] bl_n[2] bl[3] bl_n[3] bl[4] bl_n[4] bl[5] bl_n[5] bl[6] bl_n[6] bl[7] bl_n[7] bl[8] bl_n[8] bl[9] bl_n[9] bl[10] bl_n[10] bl[11] bl_n[11] bl[12] bl_n[12] bl[13] bl_n[13] bl[14] bl_n[14] bl[15] bl_n[15] bl[16] bl_n[16] bl[17] bl_n[17] bl[18] bl_n[18] bl[19] bl_n[19] bl[20] bl_n[20] bl[21] bl_n[21] bl[22] bl_n[22] bl[23] bl_n[23] bl[24] bl_n[24] bl[25] bl_n[25] bl[26] bl_n[26] bl[27] bl_n[27] bl[28] bl_n[28] bl[29] bl_n[29] bl[30] bl_n[30] bl[31] bl_n[31] SP6T2BulkConnRow_32C
.ends SP6T2Array_128X32BC

.subckt SP6T2Precharge_26L100W vdd nwell bl bl_n precharge_n
Xpc1 vdd precharge_n bl nwell sg13_lv_pmos l=1.3e-07 w=5e-07
Xpc2 bl precharge_n bl_n nwell sg13_lv_pmos l=1.3e-07 w=5e-07
Xpc3 bl_n precharge_n vdd nwell sg13_lv_pmos l=1.3e-07 w=5e-07
.ends SP6T2Precharge_26L100W

.subckt SP6T2ColMux_4MN26L580W1R bl[0] bl_n[0] mux[0] bl[1] bl_n[1] mux[1] bl[2] bl_n[2] mux[2] bl[3] bl_n[3] mux[3] vss muxbl muxbl_n
Xpgbl0 muxbl mux[0] bl[0] vss sg13_lv_nmos l=1.3e-07 w=2.9e-06
Xpgbln0 bl_n[0] mux[0] muxbl_n vss sg13_lv_nmos l=1.3e-07 w=2.9e-06
Xpgbl1 bl[1] mux[1] muxbl vss sg13_lv_nmos l=1.3e-07 w=2.9e-06
Xpgbln1 muxbl_n mux[1] bl_n[1] vss sg13_lv_nmos l=1.3e-07 w=2.9e-06
Xpgbl2 muxbl mux[2] bl[2] vss sg13_lv_nmos l=1.3e-07 w=2.9e-06
Xpgbln2 bl_n[2] mux[2] muxbl_n vss sg13_lv_nmos l=1.3e-07 w=2.9e-06
Xpgbl3 bl[3] mux[3] muxbl vss sg13_lv_nmos l=1.3e-07 w=2.9e-06
Xpgbln3 muxbl_n mux[3] bl_n[3] vss sg13_lv_nmos l=1.3e-07 w=2.9e-06
.ends SP6T2ColMux_4MN26L580W1R

.subckt SP6T2ReadWrite_CM4MN26L580W1R_WD26L380W vss vdd d q bl bl_n clk we_n
Xsenseamp vdd vss bl_n bl q noconn nsnrlatch_x1
Xd_ff vdd vss d clk d_l dff_x1
Xd_inv vdd vss d_l d_n inv_x0
Xnora vdd vss bl_pd_g d_l we_n nor2_x0
Xnorb vdd vss bln_pd_g d_n we_n nor2_x0
Xbl_pd bl bl_pd_g vss vss sg13_lv_nmos l=1.3e-07 w=1.9e-06
Xbln_pd vss bln_pd_g bl_n vss sg13_lv_nmos l=1.3e-07 w=1.9e-06
.ends SP6T2ReadWrite_CM4MN26L580W1R_WD26L380W

.subckt SP6T2ClockWE vss vdd clkup clkdown we we_en we_n
Xclkbuf vdd vss clkup clkdown buf_x2
Xweff vdd vss we clkdown we_l dff_x1
Xwenand vdd vss we_n we_l we_en nand2_x0
.ends SP6T2ClockWE

.subckt SP6T2ColPeriph8B_PC26L100W_CM4MN26L580W1R vss vdd nwell clk precharge_n we we_en q[0] d[0] bl[0] bl_n[0] bl[1] bl_n[1] bl[2] bl_n[2] bl[3] bl_n[3] q[1] d[1] bl[4] bl_n[4] bl[5] bl_n[5] bl[6] bl_n[6] bl[7] bl_n[7] q[2] d[2] bl[8] bl_n[8] bl[9] bl_n[9] bl[10] bl_n[10] bl[11] bl_n[11] q[3] d[3] bl[12] bl_n[12] bl[13] bl_n[13] bl[14] bl_n[14] bl[15] bl_n[15] q[4] d[4] bl[16] bl_n[16] bl[17] bl_n[17] bl[18] bl_n[18] bl[19] bl_n[19] q[5] d[5] bl[20] bl_n[20] bl[21] bl_n[21] bl[22] bl_n[22] bl[23] bl_n[23] q[6] d[6] bl[24] bl_n[24] bl[25] bl_n[25] bl[26] bl_n[26] bl[27] bl_n[27] q[7] d[7] bl[28] bl_n[28] bl[29] bl_n[29] bl[30] bl_n[30] bl[31] bl_n[31] mux[0] mux[1] mux[2] mux[3]
Xprecharge[0] vdd nwell bl[0] bl_n[0] precharge_n SP6T2Precharge_26L100W
Xprecharge[1] vdd nwell bl[1] bl_n[1] precharge_n SP6T2Precharge_26L100W
Xprecharge[2] vdd nwell bl[2] bl_n[2] precharge_n SP6T2Precharge_26L100W
Xprecharge[3] vdd nwell bl[3] bl_n[3] precharge_n SP6T2Precharge_26L100W
Xprecharge[4] vdd nwell bl[4] bl_n[4] precharge_n SP6T2Precharge_26L100W
Xprecharge[5] vdd nwell bl[5] bl_n[5] precharge_n SP6T2Precharge_26L100W
Xprecharge[6] vdd nwell bl[6] bl_n[6] precharge_n SP6T2Precharge_26L100W
Xprecharge[7] vdd nwell bl[7] bl_n[7] precharge_n SP6T2Precharge_26L100W
Xprecharge[8] vdd nwell bl[8] bl_n[8] precharge_n SP6T2Precharge_26L100W
Xprecharge[9] vdd nwell bl[9] bl_n[9] precharge_n SP6T2Precharge_26L100W
Xprecharge[10] vdd nwell bl[10] bl_n[10] precharge_n SP6T2Precharge_26L100W
Xprecharge[11] vdd nwell bl[11] bl_n[11] precharge_n SP6T2Precharge_26L100W
Xprecharge[12] vdd nwell bl[12] bl_n[12] precharge_n SP6T2Precharge_26L100W
Xprecharge[13] vdd nwell bl[13] bl_n[13] precharge_n SP6T2Precharge_26L100W
Xprecharge[14] vdd nwell bl[14] bl_n[14] precharge_n SP6T2Precharge_26L100W
Xprecharge[15] vdd nwell bl[15] bl_n[15] precharge_n SP6T2Precharge_26L100W
Xprecharge[16] vdd nwell bl[16] bl_n[16] precharge_n SP6T2Precharge_26L100W
Xprecharge[17] vdd nwell bl[17] bl_n[17] precharge_n SP6T2Precharge_26L100W
Xprecharge[18] vdd nwell bl[18] bl_n[18] precharge_n SP6T2Precharge_26L100W
Xprecharge[19] vdd nwell bl[19] bl_n[19] precharge_n SP6T2Precharge_26L100W
Xprecharge[20] vdd nwell bl[20] bl_n[20] precharge_n SP6T2Precharge_26L100W
Xprecharge[21] vdd nwell bl[21] bl_n[21] precharge_n SP6T2Precharge_26L100W
Xprecharge[22] vdd nwell bl[22] bl_n[22] precharge_n SP6T2Precharge_26L100W
Xprecharge[23] vdd nwell bl[23] bl_n[23] precharge_n SP6T2Precharge_26L100W
Xprecharge[24] vdd nwell bl[24] bl_n[24] precharge_n SP6T2Precharge_26L100W
Xprecharge[25] vdd nwell bl[25] bl_n[25] precharge_n SP6T2Precharge_26L100W
Xprecharge[26] vdd nwell bl[26] bl_n[26] precharge_n SP6T2Precharge_26L100W
Xprecharge[27] vdd nwell bl[27] bl_n[27] precharge_n SP6T2Precharge_26L100W
Xprecharge[28] vdd nwell bl[28] bl_n[28] precharge_n SP6T2Precharge_26L100W
Xprecharge[29] vdd nwell bl[29] bl_n[29] precharge_n SP6T2Precharge_26L100W
Xprecharge[30] vdd nwell bl[30] bl_n[30] precharge_n SP6T2Precharge_26L100W
Xprecharge[31] vdd nwell bl[31] bl_n[31] precharge_n SP6T2Precharge_26L100W
Xcolmux[0] bl[0] bl_n[0] mux[0] bl[1] bl_n[1] mux[1] bl[2] bl_n[2] mux[2] bl[3] bl_n[3] mux[3] vss muxbl[0] muxbl_n[0] SP6T2ColMux_4MN26L580W1R
Xcolmux[1] bl[4] bl_n[4] mux[0] bl[5] bl_n[5] mux[1] bl[6] bl_n[6] mux[2] bl[7] bl_n[7] mux[3] vss muxbl[1] muxbl_n[1] SP6T2ColMux_4MN26L580W1R
Xcolmux[2] bl[8] bl_n[8] mux[0] bl[9] bl_n[9] mux[1] bl[10] bl_n[10] mux[2] bl[11] bl_n[11] mux[3] vss muxbl[2] muxbl_n[2] SP6T2ColMux_4MN26L580W1R
Xcolmux[3] bl[12] bl_n[12] mux[0] bl[13] bl_n[13] mux[1] bl[14] bl_n[14] mux[2] bl[15] bl_n[15] mux[3] vss muxbl[3] muxbl_n[3] SP6T2ColMux_4MN26L580W1R
Xcolmux[4] bl[16] bl_n[16] mux[0] bl[17] bl_n[17] mux[1] bl[18] bl_n[18] mux[2] bl[19] bl_n[19] mux[3] vss muxbl[4] muxbl_n[4] SP6T2ColMux_4MN26L580W1R
Xcolmux[5] bl[20] bl_n[20] mux[0] bl[21] bl_n[21] mux[1] bl[22] bl_n[22] mux[2] bl[23] bl_n[23] mux[3] vss muxbl[5] muxbl_n[5] SP6T2ColMux_4MN26L580W1R
Xcolmux[6] bl[24] bl_n[24] mux[0] bl[25] bl_n[25] mux[1] bl[26] bl_n[26] mux[2] bl[27] bl_n[27] mux[3] vss muxbl[6] muxbl_n[6] SP6T2ColMux_4MN26L580W1R
Xcolmux[7] bl[28] bl_n[28] mux[0] bl[29] bl_n[29] mux[1] bl[30] bl_n[30] mux[2] bl[31] bl_n[31] mux[3] vss muxbl[7] muxbl_n[7] SP6T2ColMux_4MN26L580W1R
Xrw[0] vss vdd d[0] q[0] muxbl[0] muxbl_n[0] intclk we_n SP6T2ReadWrite_CM4MN26L580W1R_WD26L380W
Xrw[1] vss vdd d[1] q[1] muxbl[1] muxbl_n[1] intclk we_n SP6T2ReadWrite_CM4MN26L580W1R_WD26L380W
Xrw[2] vss vdd d[2] q[2] muxbl[2] muxbl_n[2] intclk we_n SP6T2ReadWrite_CM4MN26L580W1R_WD26L380W
Xrw[3] vss vdd d[3] q[3] muxbl[3] muxbl_n[3] intclk we_n SP6T2ReadWrite_CM4MN26L580W1R_WD26L380W
Xrw[4] vss vdd d[4] q[4] muxbl[4] muxbl_n[4] intclk we_n SP6T2ReadWrite_CM4MN26L580W1R_WD26L380W
Xrw[5] vss vdd d[5] q[5] muxbl[5] muxbl_n[5] intclk we_n SP6T2ReadWrite_CM4MN26L580W1R_WD26L380W
Xrw[6] vss vdd d[6] q[6] muxbl[6] muxbl_n[6] intclk we_n SP6T2ReadWrite_CM4MN26L580W1R_WD26L380W
Xrw[7] vss vdd d[7] q[7] muxbl[7] muxbl_n[7] intclk we_n SP6T2ReadWrite_CM4MN26L580W1R_WD26L380W
Xclkwe vss vdd clk intclk we we_en we_n SP6T2ClockWE
.ends SP6T2ColPeriph8B_PC26L100W_CM4MN26L580W1R

.subckt SP6T2Column_128R_CP8B_CM4MN26L580W1R_PC26L100W vss vdd wl[0] wl[1] wl[2] wl[3] wl[4] wl[5] wl[6] wl[7] wl[8] wl[9] wl[10] wl[11] wl[12] wl[13] wl[14] wl[15] wl[16] wl[17] wl[18] wl[19] wl[20] wl[21] wl[22] wl[23] wl[24] wl[25] wl[26] wl[27] wl[28] wl[29] wl[30] wl[31] wl[32] wl[33] wl[34] wl[35] wl[36] wl[37] wl[38] wl[39] wl[40] wl[41] wl[42] wl[43] wl[44] wl[45] wl[46] wl[47] wl[48] wl[49] wl[50] wl[51] wl[52] wl[53] wl[54] wl[55] wl[56] wl[57] wl[58] wl[59] wl[60] wl[61] wl[62] wl[63] wl[64] wl[65] wl[66] wl[67] wl[68] wl[69] wl[70] wl[71] wl[72] wl[73] wl[74] wl[75] wl[76] wl[77] wl[78] wl[79] wl[80] wl[81] wl[82] wl[83] wl[84] wl[85] wl[86] wl[87] wl[88] wl[89] wl[90] wl[91] wl[92] wl[93] wl[94] wl[95] wl[96] wl[97] wl[98] wl[99] wl[100] wl[101] wl[102] wl[103] wl[104] wl[105] wl[106] wl[107] wl[108] wl[109] wl[110] wl[111] wl[112] wl[113] wl[114] wl[115] wl[116] wl[117] wl[118] wl[119] wl[120] wl[121] wl[122] wl[123] wl[124] wl[125] wl[126] wl[127] q[0] d[0] q[1] d[1] q[2] d[2] q[3] d[3] q[4] d[4] q[5] d[5] q[6] d[6] q[7] d[7] we clk we_en precharge_n mux[0] mux[1] mux[2] mux[3]
Xarray vss vdd wl[0] wl[1] wl[2] wl[3] wl[4] wl[5] wl[6] wl[7] wl[8] wl[9] wl[10] wl[11] wl[12] wl[13] wl[14] wl[15] wl[16] wl[17] wl[18] wl[19] wl[20] wl[21] wl[22] wl[23] wl[24] wl[25] wl[26] wl[27] wl[28] wl[29] wl[30] wl[31] wl[32] wl[33] wl[34] wl[35] wl[36] wl[37] wl[38] wl[39] wl[40] wl[41] wl[42] wl[43] wl[44] wl[45] wl[46] wl[47] wl[48] wl[49] wl[50] wl[51] wl[52] wl[53] wl[54] wl[55] wl[56] wl[57] wl[58] wl[59] wl[60] wl[61] wl[62] wl[63] wl[64] wl[65] wl[66] wl[67] wl[68] wl[69] wl[70] wl[71] wl[72] wl[73] wl[74] wl[75] wl[76] wl[77] wl[78] wl[79] wl[80] wl[81] wl[82] wl[83] wl[84] wl[85] wl[86] wl[87] wl[88] wl[89] wl[90] wl[91] wl[92] wl[93] wl[94] wl[95] wl[96] wl[97] wl[98] wl[99] wl[100] wl[101] wl[102] wl[103] wl[104] wl[105] wl[106] wl[107] wl[108] wl[109] wl[110] wl[111] wl[112] wl[113] wl[114] wl[115] wl[116] wl[117] wl[118] wl[119] wl[120] wl[121] wl[122] wl[123] wl[124] wl[125] wl[126] wl[127] bl[0] bl_n[0] bl[1] bl_n[1] bl[2] bl_n[2] bl[3] bl_n[3] bl[4] bl_n[4] bl[5] bl_n[5] bl[6] bl_n[6] bl[7] bl_n[7] bl[8] bl_n[8] bl[9] bl_n[9] bl[10] bl_n[10] bl[11] bl_n[11] bl[12] bl_n[12] bl[13] bl_n[13] bl[14] bl_n[14] bl[15] bl_n[15] bl[16] bl_n[16] bl[17] bl_n[17] bl[18] bl_n[18] bl[19] bl_n[19] bl[20] bl_n[20] bl[21] bl_n[21] bl[22] bl_n[22] bl[23] bl_n[23] bl[24] bl_n[24] bl[25] bl_n[25] bl[26] bl_n[26] bl[27] bl_n[27] bl[28] bl_n[28] bl[29] bl_n[29] bl[30] bl_n[30] bl[31] bl_n[31] SP6T2Array_128X32BC
Xperiph vss vdd vdd clk precharge_n we we_en q[0] d[0] bl[0] bl_n[0] bl[1] bl_n[1] bl[2] bl_n[2] bl[3] bl_n[3] q[1] d[1] bl[4] bl_n[4] bl[5] bl_n[5] bl[6] bl_n[6] bl[7] bl_n[7] q[2] d[2] bl[8] bl_n[8] bl[9] bl_n[9] bl[10] bl_n[10] bl[11] bl_n[11] q[3] d[3] bl[12] bl_n[12] bl[13] bl_n[13] bl[14] bl_n[14] bl[15] bl_n[15] q[4] d[4] bl[16] bl_n[16] bl[17] bl_n[17] bl[18] bl_n[18] bl[19] bl_n[19] q[5] d[5] bl[20] bl_n[20] bl[21] bl_n[21] bl[22] bl_n[22] bl[23] bl_n[23] q[6] d[6] bl[24] bl_n[24] bl[25] bl_n[25] bl[26] bl_n[26] bl[27] bl_n[27] q[7] d[7] bl[28] bl_n[28] bl[29] bl_n[29] bl[30] bl_n[30] bl[31] bl_n[31] mux[0] mux[1] mux[2] mux[3] SP6T2ColPeriph8B_PC26L100W_CM4MN26L580W1R
.ends SP6T2Column_128R_CP8B_CM4MN26L580W1R_PC26L100W

.subckt SP6T2ColumnBlock_COL128R_CP8B_CM4MN26L580W1R_PC26L100W_4WE vss vdd clk precharge_n we_en wl[0] wl[1] wl[2] wl[3] wl[4] wl[5] wl[6] wl[7] wl[8] wl[9] wl[10] wl[11] wl[12] wl[13] wl[14] wl[15] wl[16] wl[17] wl[18] wl[19] wl[20] wl[21] wl[22] wl[23] wl[24] wl[25] wl[26] wl[27] wl[28] wl[29] wl[30] wl[31] wl[32] wl[33] wl[34] wl[35] wl[36] wl[37] wl[38] wl[39] wl[40] wl[41] wl[42] wl[43] wl[44] wl[45] wl[46] wl[47] wl[48] wl[49] wl[50] wl[51] wl[52] wl[53] wl[54] wl[55] wl[56] wl[57] wl[58] wl[59] wl[60] wl[61] wl[62] wl[63] wl[64] wl[65] wl[66] wl[67] wl[68] wl[69] wl[70] wl[71] wl[72] wl[73] wl[74] wl[75] wl[76] wl[77] wl[78] wl[79] wl[80] wl[81] wl[82] wl[83] wl[84] wl[85] wl[86] wl[87] wl[88] wl[89] wl[90] wl[91] wl[92] wl[93] wl[94] wl[95] wl[96] wl[97] wl[98] wl[99] wl[100] wl[101] wl[102] wl[103] wl[104] wl[105] wl[106] wl[107] wl[108] wl[109] wl[110] wl[111] wl[112] wl[113] wl[114] wl[115] wl[116] wl[117] wl[118] wl[119] wl[120] wl[121] wl[122] wl[123] wl[124] wl[125] wl[126] wl[127] mux[0] mux[1] mux[2] mux[3] we[0] q[0] d[0] q[1] d[1] q[2] d[2] q[3] d[3] q[4] d[4] q[5] d[5] q[6] d[6] q[7] d[7] we[1] q[8] d[8] q[9] d[9] q[10] d[10] q[11] d[11] q[12] d[12] q[13] d[13] q[14] d[14] q[15] d[15] we[2] q[16] d[16] q[17] d[17] q[18] d[18] q[19] d[19] q[20] d[20] q[21] d[21] q[22] d[22] q[23] d[23] we[3] q[24] d[24] q[25] d[25] q[26] d[26] q[27] d[27] q[28] d[28] q[29] d[29] q[30] d[30] q[31] d[31]
Xcolumn[0] vss vdd wl[0] wl[1] wl[2] wl[3] wl[4] wl[5] wl[6] wl[7] wl[8] wl[9] wl[10] wl[11] wl[12] wl[13] wl[14] wl[15] wl[16] wl[17] wl[18] wl[19] wl[20] wl[21] wl[22] wl[23] wl[24] wl[25] wl[26] wl[27] wl[28] wl[29] wl[30] wl[31] wl[32] wl[33] wl[34] wl[35] wl[36] wl[37] wl[38] wl[39] wl[40] wl[41] wl[42] wl[43] wl[44] wl[45] wl[46] wl[47] wl[48] wl[49] wl[50] wl[51] wl[52] wl[53] wl[54] wl[55] wl[56] wl[57] wl[58] wl[59] wl[60] wl[61] wl[62] wl[63] wl[64] wl[65] wl[66] wl[67] wl[68] wl[69] wl[70] wl[71] wl[72] wl[73] wl[74] wl[75] wl[76] wl[77] wl[78] wl[79] wl[80] wl[81] wl[82] wl[83] wl[84] wl[85] wl[86] wl[87] wl[88] wl[89] wl[90] wl[91] wl[92] wl[93] wl[94] wl[95] wl[96] wl[97] wl[98] wl[99] wl[100] wl[101] wl[102] wl[103] wl[104] wl[105] wl[106] wl[107] wl[108] wl[109] wl[110] wl[111] wl[112] wl[113] wl[114] wl[115] wl[116] wl[117] wl[118] wl[119] wl[120] wl[121] wl[122] wl[123] wl[124] wl[125] wl[126] wl[127] q[0] d[0] q[1] d[1] q[2] d[2] q[3] d[3] q[4] d[4] q[5] d[5] q[6] d[6] q[7] d[7] we[0] clk we_en precharge_n mux[0] mux[1] mux[2] mux[3] SP6T2Column_128R_CP8B_CM4MN26L580W1R_PC26L100W
Xcolumn[1] vss vdd wl[0] wl[1] wl[2] wl[3] wl[4] wl[5] wl[6] wl[7] wl[8] wl[9] wl[10] wl[11] wl[12] wl[13] wl[14] wl[15] wl[16] wl[17] wl[18] wl[19] wl[20] wl[21] wl[22] wl[23] wl[24] wl[25] wl[26] wl[27] wl[28] wl[29] wl[30] wl[31] wl[32] wl[33] wl[34] wl[35] wl[36] wl[37] wl[38] wl[39] wl[40] wl[41] wl[42] wl[43] wl[44] wl[45] wl[46] wl[47] wl[48] wl[49] wl[50] wl[51] wl[52] wl[53] wl[54] wl[55] wl[56] wl[57] wl[58] wl[59] wl[60] wl[61] wl[62] wl[63] wl[64] wl[65] wl[66] wl[67] wl[68] wl[69] wl[70] wl[71] wl[72] wl[73] wl[74] wl[75] wl[76] wl[77] wl[78] wl[79] wl[80] wl[81] wl[82] wl[83] wl[84] wl[85] wl[86] wl[87] wl[88] wl[89] wl[90] wl[91] wl[92] wl[93] wl[94] wl[95] wl[96] wl[97] wl[98] wl[99] wl[100] wl[101] wl[102] wl[103] wl[104] wl[105] wl[106] wl[107] wl[108] wl[109] wl[110] wl[111] wl[112] wl[113] wl[114] wl[115] wl[116] wl[117] wl[118] wl[119] wl[120] wl[121] wl[122] wl[123] wl[124] wl[125] wl[126] wl[127] q[8] d[8] q[9] d[9] q[10] d[10] q[11] d[11] q[12] d[12] q[13] d[13] q[14] d[14] q[15] d[15] we[1] clk we_en precharge_n mux[0] mux[1] mux[2] mux[3] SP6T2Column_128R_CP8B_CM4MN26L580W1R_PC26L100W
Xcolumn[2] vss vdd wl[0] wl[1] wl[2] wl[3] wl[4] wl[5] wl[6] wl[7] wl[8] wl[9] wl[10] wl[11] wl[12] wl[13] wl[14] wl[15] wl[16] wl[17] wl[18] wl[19] wl[20] wl[21] wl[22] wl[23] wl[24] wl[25] wl[26] wl[27] wl[28] wl[29] wl[30] wl[31] wl[32] wl[33] wl[34] wl[35] wl[36] wl[37] wl[38] wl[39] wl[40] wl[41] wl[42] wl[43] wl[44] wl[45] wl[46] wl[47] wl[48] wl[49] wl[50] wl[51] wl[52] wl[53] wl[54] wl[55] wl[56] wl[57] wl[58] wl[59] wl[60] wl[61] wl[62] wl[63] wl[64] wl[65] wl[66] wl[67] wl[68] wl[69] wl[70] wl[71] wl[72] wl[73] wl[74] wl[75] wl[76] wl[77] wl[78] wl[79] wl[80] wl[81] wl[82] wl[83] wl[84] wl[85] wl[86] wl[87] wl[88] wl[89] wl[90] wl[91] wl[92] wl[93] wl[94] wl[95] wl[96] wl[97] wl[98] wl[99] wl[100] wl[101] wl[102] wl[103] wl[104] wl[105] wl[106] wl[107] wl[108] wl[109] wl[110] wl[111] wl[112] wl[113] wl[114] wl[115] wl[116] wl[117] wl[118] wl[119] wl[120] wl[121] wl[122] wl[123] wl[124] wl[125] wl[126] wl[127] q[16] d[16] q[17] d[17] q[18] d[18] q[19] d[19] q[20] d[20] q[21] d[21] q[22] d[22] q[23] d[23] we[2] clk we_en precharge_n mux[0] mux[1] mux[2] mux[3] SP6T2Column_128R_CP8B_CM4MN26L580W1R_PC26L100W
Xcolumn[3] vss vdd wl[0] wl[1] wl[2] wl[3] wl[4] wl[5] wl[6] wl[7] wl[8] wl[9] wl[10] wl[11] wl[12] wl[13] wl[14] wl[15] wl[16] wl[17] wl[18] wl[19] wl[20] wl[21] wl[22] wl[23] wl[24] wl[25] wl[26] wl[27] wl[28] wl[29] wl[30] wl[31] wl[32] wl[33] wl[34] wl[35] wl[36] wl[37] wl[38] wl[39] wl[40] wl[41] wl[42] wl[43] wl[44] wl[45] wl[46] wl[47] wl[48] wl[49] wl[50] wl[51] wl[52] wl[53] wl[54] wl[55] wl[56] wl[57] wl[58] wl[59] wl[60] wl[61] wl[62] wl[63] wl[64] wl[65] wl[66] wl[67] wl[68] wl[69] wl[70] wl[71] wl[72] wl[73] wl[74] wl[75] wl[76] wl[77] wl[78] wl[79] wl[80] wl[81] wl[82] wl[83] wl[84] wl[85] wl[86] wl[87] wl[88] wl[89] wl[90] wl[91] wl[92] wl[93] wl[94] wl[95] wl[96] wl[97] wl[98] wl[99] wl[100] wl[101] wl[102] wl[103] wl[104] wl[105] wl[106] wl[107] wl[108] wl[109] wl[110] wl[111] wl[112] wl[113] wl[114] wl[115] wl[116] wl[117] wl[118] wl[119] wl[120] wl[121] wl[122] wl[123] wl[124] wl[125] wl[126] wl[127] q[24] d[24] q[25] d[25] q[26] d[26] q[27] d[27] q[28] d[28] q[29] d[29] q[30] d[30] q[31] d[31] we[3] clk we_en precharge_n mux[0] mux[1] mux[2] mux[3] SP6T2Column_128R_CP8B_CM4MN26L580W1R_PC26L100W
.ends SP6T2ColumnBlock_COL128R_CP8B_CM4MN26L580W1R_PC26L100W_4WE

.subckt SP6T2WLDriver_N26L400WP26L800W vss substrate vdd nwell wl_n wl_drive
Xnmos1 vss wl_n wl_drive substrate sg13_lv_nmos l=1.3e-07 w=2e-06
Xnmos2 wl_drive wl_n vss substrate sg13_lv_nmos l=1.3e-07 w=2e-06
Xpmos1 vdd wl_n wl_drive nwell sg13_lv_pmos l=1.3e-07 w=4e-06
Xpmos2 wl_drive wl_n vdd nwell sg13_lv_pmos l=1.3e-07 w=4e-06
.ends SP6T2WLDriver_N26L400WP26L800W

.subckt SP6T2WLDriverBC_N26L400WP26L800W vss vdd
.ends SP6T2WLDriverBC_N26L400WP26L800W

.subckt SP6T2WLDriverCol_128RN26L400WP26L800W vss vdd wl[0] wl_n[0] wl[1] wl_n[1] wl[2] wl_n[2] wl[3] wl_n[3] wl[4] wl_n[4] wl[5] wl_n[5] wl[6] wl_n[6] wl[7] wl_n[7] wl[8] wl_n[8] wl[9] wl_n[9] wl[10] wl_n[10] wl[11] wl_n[11] wl[12] wl_n[12] wl[13] wl_n[13] wl[14] wl_n[14] wl[15] wl_n[15] wl[16] wl_n[16] wl[17] wl_n[17] wl[18] wl_n[18] wl[19] wl_n[19] wl[20] wl_n[20] wl[21] wl_n[21] wl[22] wl_n[22] wl[23] wl_n[23] wl[24] wl_n[24] wl[25] wl_n[25] wl[26] wl_n[26] wl[27] wl_n[27] wl[28] wl_n[28] wl[29] wl_n[29] wl[30] wl_n[30] wl[31] wl_n[31] wl[32] wl_n[32] wl[33] wl_n[33] wl[34] wl_n[34] wl[35] wl_n[35] wl[36] wl_n[36] wl[37] wl_n[37] wl[38] wl_n[38] wl[39] wl_n[39] wl[40] wl_n[40] wl[41] wl_n[41] wl[42] wl_n[42] wl[43] wl_n[43] wl[44] wl_n[44] wl[45] wl_n[45] wl[46] wl_n[46] wl[47] wl_n[47] wl[48] wl_n[48] wl[49] wl_n[49] wl[50] wl_n[50] wl[51] wl_n[51] wl[52] wl_n[52] wl[53] wl_n[53] wl[54] wl_n[54] wl[55] wl_n[55] wl[56] wl_n[56] wl[57] wl_n[57] wl[58] wl_n[58] wl[59] wl_n[59] wl[60] wl_n[60] wl[61] wl_n[61] wl[62] wl_n[62] wl[63] wl_n[63] wl[64] wl_n[64] wl[65] wl_n[65] wl[66] wl_n[66] wl[67] wl_n[67] wl[68] wl_n[68] wl[69] wl_n[69] wl[70] wl_n[70] wl[71] wl_n[71] wl[72] wl_n[72] wl[73] wl_n[73] wl[74] wl_n[74] wl[75] wl_n[75] wl[76] wl_n[76] wl[77] wl_n[77] wl[78] wl_n[78] wl[79] wl_n[79] wl[80] wl_n[80] wl[81] wl_n[81] wl[82] wl_n[82] wl[83] wl_n[83] wl[84] wl_n[84] wl[85] wl_n[85] wl[86] wl_n[86] wl[87] wl_n[87] wl[88] wl_n[88] wl[89] wl_n[89] wl[90] wl_n[90] wl[91] wl_n[91] wl[92] wl_n[92] wl[93] wl_n[93] wl[94] wl_n[94] wl[95] wl_n[95] wl[96] wl_n[96] wl[97] wl_n[97] wl[98] wl_n[98] wl[99] wl_n[99] wl[100] wl_n[100] wl[101] wl_n[101] wl[102] wl_n[102] wl[103] wl_n[103] wl[104] wl_n[104] wl[105] wl_n[105] wl[106] wl_n[106] wl[107] wl_n[107] wl[108] wl_n[108] wl[109] wl_n[109] wl[110] wl_n[110] wl[111] wl_n[111] wl[112] wl_n[112] wl[113] wl_n[113] wl[114] wl_n[114] wl[115] wl_n[115] wl[116] wl_n[116] wl[117] wl_n[117] wl[118] wl_n[118] wl[119] wl_n[119] wl[120] wl_n[120] wl[121] wl_n[121] wl[122] wl_n[122] wl[123] wl_n[123] wl[124] wl_n[124] wl[125] wl_n[125] wl[126] wl_n[126] wl[127] wl_n[127]
Xdriver[0] vss vss vdd vdd wl_n[0] wl[0] SP6T2WLDriver_N26L400WP26L800W
Xdriver[1] vss vss vdd vdd wl_n[1] wl[1] SP6T2WLDriver_N26L400WP26L800W
Xdriver[2] vss vss vdd vdd wl_n[2] wl[2] SP6T2WLDriver_N26L400WP26L800W
Xdriver[3] vss vss vdd vdd wl_n[3] wl[3] SP6T2WLDriver_N26L400WP26L800W
Xdriver[4] vss vss vdd vdd wl_n[4] wl[4] SP6T2WLDriver_N26L400WP26L800W
Xdriver[5] vss vss vdd vdd wl_n[5] wl[5] SP6T2WLDriver_N26L400WP26L800W
Xdriver[6] vss vss vdd vdd wl_n[6] wl[6] SP6T2WLDriver_N26L400WP26L800W
Xdriver[7] vss vss vdd vdd wl_n[7] wl[7] SP6T2WLDriver_N26L400WP26L800W
Xdriver[8] vss vss vdd vdd wl_n[8] wl[8] SP6T2WLDriver_N26L400WP26L800W
Xdriver[9] vss vss vdd vdd wl_n[9] wl[9] SP6T2WLDriver_N26L400WP26L800W
Xdriver[10] vss vss vdd vdd wl_n[10] wl[10] SP6T2WLDriver_N26L400WP26L800W
Xdriver[11] vss vss vdd vdd wl_n[11] wl[11] SP6T2WLDriver_N26L400WP26L800W
Xdriver[12] vss vss vdd vdd wl_n[12] wl[12] SP6T2WLDriver_N26L400WP26L800W
Xdriver[13] vss vss vdd vdd wl_n[13] wl[13] SP6T2WLDriver_N26L400WP26L800W
Xdriver[14] vss vss vdd vdd wl_n[14] wl[14] SP6T2WLDriver_N26L400WP26L800W
Xdriver[15] vss vss vdd vdd wl_n[15] wl[15] SP6T2WLDriver_N26L400WP26L800W
Xdriver[16] vss vss vdd vdd wl_n[16] wl[16] SP6T2WLDriver_N26L400WP26L800W
Xdriver[17] vss vss vdd vdd wl_n[17] wl[17] SP6T2WLDriver_N26L400WP26L800W
Xdriver[18] vss vss vdd vdd wl_n[18] wl[18] SP6T2WLDriver_N26L400WP26L800W
Xdriver[19] vss vss vdd vdd wl_n[19] wl[19] SP6T2WLDriver_N26L400WP26L800W
Xdriver[20] vss vss vdd vdd wl_n[20] wl[20] SP6T2WLDriver_N26L400WP26L800W
Xdriver[21] vss vss vdd vdd wl_n[21] wl[21] SP6T2WLDriver_N26L400WP26L800W
Xdriver[22] vss vss vdd vdd wl_n[22] wl[22] SP6T2WLDriver_N26L400WP26L800W
Xdriver[23] vss vss vdd vdd wl_n[23] wl[23] SP6T2WLDriver_N26L400WP26L800W
Xdriver[24] vss vss vdd vdd wl_n[24] wl[24] SP6T2WLDriver_N26L400WP26L800W
Xdriver[25] vss vss vdd vdd wl_n[25] wl[25] SP6T2WLDriver_N26L400WP26L800W
Xdriver[26] vss vss vdd vdd wl_n[26] wl[26] SP6T2WLDriver_N26L400WP26L800W
Xdriver[27] vss vss vdd vdd wl_n[27] wl[27] SP6T2WLDriver_N26L400WP26L800W
Xdriver[28] vss vss vdd vdd wl_n[28] wl[28] SP6T2WLDriver_N26L400WP26L800W
Xdriver[29] vss vss vdd vdd wl_n[29] wl[29] SP6T2WLDriver_N26L400WP26L800W
Xdriver[30] vss vss vdd vdd wl_n[30] wl[30] SP6T2WLDriver_N26L400WP26L800W
Xdriver[31] vss vss vdd vdd wl_n[31] wl[31] SP6T2WLDriver_N26L400WP26L800W
Xdriver[32] vss vss vdd vdd wl_n[32] wl[32] SP6T2WLDriver_N26L400WP26L800W
Xdriver[33] vss vss vdd vdd wl_n[33] wl[33] SP6T2WLDriver_N26L400WP26L800W
Xdriver[34] vss vss vdd vdd wl_n[34] wl[34] SP6T2WLDriver_N26L400WP26L800W
Xdriver[35] vss vss vdd vdd wl_n[35] wl[35] SP6T2WLDriver_N26L400WP26L800W
Xdriver[36] vss vss vdd vdd wl_n[36] wl[36] SP6T2WLDriver_N26L400WP26L800W
Xdriver[37] vss vss vdd vdd wl_n[37] wl[37] SP6T2WLDriver_N26L400WP26L800W
Xdriver[38] vss vss vdd vdd wl_n[38] wl[38] SP6T2WLDriver_N26L400WP26L800W
Xdriver[39] vss vss vdd vdd wl_n[39] wl[39] SP6T2WLDriver_N26L400WP26L800W
Xdriver[40] vss vss vdd vdd wl_n[40] wl[40] SP6T2WLDriver_N26L400WP26L800W
Xdriver[41] vss vss vdd vdd wl_n[41] wl[41] SP6T2WLDriver_N26L400WP26L800W
Xdriver[42] vss vss vdd vdd wl_n[42] wl[42] SP6T2WLDriver_N26L400WP26L800W
Xdriver[43] vss vss vdd vdd wl_n[43] wl[43] SP6T2WLDriver_N26L400WP26L800W
Xdriver[44] vss vss vdd vdd wl_n[44] wl[44] SP6T2WLDriver_N26L400WP26L800W
Xdriver[45] vss vss vdd vdd wl_n[45] wl[45] SP6T2WLDriver_N26L400WP26L800W
Xdriver[46] vss vss vdd vdd wl_n[46] wl[46] SP6T2WLDriver_N26L400WP26L800W
Xdriver[47] vss vss vdd vdd wl_n[47] wl[47] SP6T2WLDriver_N26L400WP26L800W
Xdriver[48] vss vss vdd vdd wl_n[48] wl[48] SP6T2WLDriver_N26L400WP26L800W
Xdriver[49] vss vss vdd vdd wl_n[49] wl[49] SP6T2WLDriver_N26L400WP26L800W
Xdriver[50] vss vss vdd vdd wl_n[50] wl[50] SP6T2WLDriver_N26L400WP26L800W
Xdriver[51] vss vss vdd vdd wl_n[51] wl[51] SP6T2WLDriver_N26L400WP26L800W
Xdriver[52] vss vss vdd vdd wl_n[52] wl[52] SP6T2WLDriver_N26L400WP26L800W
Xdriver[53] vss vss vdd vdd wl_n[53] wl[53] SP6T2WLDriver_N26L400WP26L800W
Xdriver[54] vss vss vdd vdd wl_n[54] wl[54] SP6T2WLDriver_N26L400WP26L800W
Xdriver[55] vss vss vdd vdd wl_n[55] wl[55] SP6T2WLDriver_N26L400WP26L800W
Xdriver[56] vss vss vdd vdd wl_n[56] wl[56] SP6T2WLDriver_N26L400WP26L800W
Xdriver[57] vss vss vdd vdd wl_n[57] wl[57] SP6T2WLDriver_N26L400WP26L800W
Xdriver[58] vss vss vdd vdd wl_n[58] wl[58] SP6T2WLDriver_N26L400WP26L800W
Xdriver[59] vss vss vdd vdd wl_n[59] wl[59] SP6T2WLDriver_N26L400WP26L800W
Xdriver[60] vss vss vdd vdd wl_n[60] wl[60] SP6T2WLDriver_N26L400WP26L800W
Xdriver[61] vss vss vdd vdd wl_n[61] wl[61] SP6T2WLDriver_N26L400WP26L800W
Xdriver[62] vss vss vdd vdd wl_n[62] wl[62] SP6T2WLDriver_N26L400WP26L800W
Xdriver[63] vss vss vdd vdd wl_n[63] wl[63] SP6T2WLDriver_N26L400WP26L800W
Xdriver[64] vss vss vdd vdd wl_n[64] wl[64] SP6T2WLDriver_N26L400WP26L800W
Xdriver[65] vss vss vdd vdd wl_n[65] wl[65] SP6T2WLDriver_N26L400WP26L800W
Xdriver[66] vss vss vdd vdd wl_n[66] wl[66] SP6T2WLDriver_N26L400WP26L800W
Xdriver[67] vss vss vdd vdd wl_n[67] wl[67] SP6T2WLDriver_N26L400WP26L800W
Xdriver[68] vss vss vdd vdd wl_n[68] wl[68] SP6T2WLDriver_N26L400WP26L800W
Xdriver[69] vss vss vdd vdd wl_n[69] wl[69] SP6T2WLDriver_N26L400WP26L800W
Xdriver[70] vss vss vdd vdd wl_n[70] wl[70] SP6T2WLDriver_N26L400WP26L800W
Xdriver[71] vss vss vdd vdd wl_n[71] wl[71] SP6T2WLDriver_N26L400WP26L800W
Xdriver[72] vss vss vdd vdd wl_n[72] wl[72] SP6T2WLDriver_N26L400WP26L800W
Xdriver[73] vss vss vdd vdd wl_n[73] wl[73] SP6T2WLDriver_N26L400WP26L800W
Xdriver[74] vss vss vdd vdd wl_n[74] wl[74] SP6T2WLDriver_N26L400WP26L800W
Xdriver[75] vss vss vdd vdd wl_n[75] wl[75] SP6T2WLDriver_N26L400WP26L800W
Xdriver[76] vss vss vdd vdd wl_n[76] wl[76] SP6T2WLDriver_N26L400WP26L800W
Xdriver[77] vss vss vdd vdd wl_n[77] wl[77] SP6T2WLDriver_N26L400WP26L800W
Xdriver[78] vss vss vdd vdd wl_n[78] wl[78] SP6T2WLDriver_N26L400WP26L800W
Xdriver[79] vss vss vdd vdd wl_n[79] wl[79] SP6T2WLDriver_N26L400WP26L800W
Xdriver[80] vss vss vdd vdd wl_n[80] wl[80] SP6T2WLDriver_N26L400WP26L800W
Xdriver[81] vss vss vdd vdd wl_n[81] wl[81] SP6T2WLDriver_N26L400WP26L800W
Xdriver[82] vss vss vdd vdd wl_n[82] wl[82] SP6T2WLDriver_N26L400WP26L800W
Xdriver[83] vss vss vdd vdd wl_n[83] wl[83] SP6T2WLDriver_N26L400WP26L800W
Xdriver[84] vss vss vdd vdd wl_n[84] wl[84] SP6T2WLDriver_N26L400WP26L800W
Xdriver[85] vss vss vdd vdd wl_n[85] wl[85] SP6T2WLDriver_N26L400WP26L800W
Xdriver[86] vss vss vdd vdd wl_n[86] wl[86] SP6T2WLDriver_N26L400WP26L800W
Xdriver[87] vss vss vdd vdd wl_n[87] wl[87] SP6T2WLDriver_N26L400WP26L800W
Xdriver[88] vss vss vdd vdd wl_n[88] wl[88] SP6T2WLDriver_N26L400WP26L800W
Xdriver[89] vss vss vdd vdd wl_n[89] wl[89] SP6T2WLDriver_N26L400WP26L800W
Xdriver[90] vss vss vdd vdd wl_n[90] wl[90] SP6T2WLDriver_N26L400WP26L800W
Xdriver[91] vss vss vdd vdd wl_n[91] wl[91] SP6T2WLDriver_N26L400WP26L800W
Xdriver[92] vss vss vdd vdd wl_n[92] wl[92] SP6T2WLDriver_N26L400WP26L800W
Xdriver[93] vss vss vdd vdd wl_n[93] wl[93] SP6T2WLDriver_N26L400WP26L800W
Xdriver[94] vss vss vdd vdd wl_n[94] wl[94] SP6T2WLDriver_N26L400WP26L800W
Xdriver[95] vss vss vdd vdd wl_n[95] wl[95] SP6T2WLDriver_N26L400WP26L800W
Xdriver[96] vss vss vdd vdd wl_n[96] wl[96] SP6T2WLDriver_N26L400WP26L800W
Xdriver[97] vss vss vdd vdd wl_n[97] wl[97] SP6T2WLDriver_N26L400WP26L800W
Xdriver[98] vss vss vdd vdd wl_n[98] wl[98] SP6T2WLDriver_N26L400WP26L800W
Xdriver[99] vss vss vdd vdd wl_n[99] wl[99] SP6T2WLDriver_N26L400WP26L800W
Xdriver[100] vss vss vdd vdd wl_n[100] wl[100] SP6T2WLDriver_N26L400WP26L800W
Xdriver[101] vss vss vdd vdd wl_n[101] wl[101] SP6T2WLDriver_N26L400WP26L800W
Xdriver[102] vss vss vdd vdd wl_n[102] wl[102] SP6T2WLDriver_N26L400WP26L800W
Xdriver[103] vss vss vdd vdd wl_n[103] wl[103] SP6T2WLDriver_N26L400WP26L800W
Xdriver[104] vss vss vdd vdd wl_n[104] wl[104] SP6T2WLDriver_N26L400WP26L800W
Xdriver[105] vss vss vdd vdd wl_n[105] wl[105] SP6T2WLDriver_N26L400WP26L800W
Xdriver[106] vss vss vdd vdd wl_n[106] wl[106] SP6T2WLDriver_N26L400WP26L800W
Xdriver[107] vss vss vdd vdd wl_n[107] wl[107] SP6T2WLDriver_N26L400WP26L800W
Xdriver[108] vss vss vdd vdd wl_n[108] wl[108] SP6T2WLDriver_N26L400WP26L800W
Xdriver[109] vss vss vdd vdd wl_n[109] wl[109] SP6T2WLDriver_N26L400WP26L800W
Xdriver[110] vss vss vdd vdd wl_n[110] wl[110] SP6T2WLDriver_N26L400WP26L800W
Xdriver[111] vss vss vdd vdd wl_n[111] wl[111] SP6T2WLDriver_N26L400WP26L800W
Xdriver[112] vss vss vdd vdd wl_n[112] wl[112] SP6T2WLDriver_N26L400WP26L800W
Xdriver[113] vss vss vdd vdd wl_n[113] wl[113] SP6T2WLDriver_N26L400WP26L800W
Xdriver[114] vss vss vdd vdd wl_n[114] wl[114] SP6T2WLDriver_N26L400WP26L800W
Xdriver[115] vss vss vdd vdd wl_n[115] wl[115] SP6T2WLDriver_N26L400WP26L800W
Xdriver[116] vss vss vdd vdd wl_n[116] wl[116] SP6T2WLDriver_N26L400WP26L800W
Xdriver[117] vss vss vdd vdd wl_n[117] wl[117] SP6T2WLDriver_N26L400WP26L800W
Xdriver[118] vss vss vdd vdd wl_n[118] wl[118] SP6T2WLDriver_N26L400WP26L800W
Xdriver[119] vss vss vdd vdd wl_n[119] wl[119] SP6T2WLDriver_N26L400WP26L800W
Xdriver[120] vss vss vdd vdd wl_n[120] wl[120] SP6T2WLDriver_N26L400WP26L800W
Xdriver[121] vss vss vdd vdd wl_n[121] wl[121] SP6T2WLDriver_N26L400WP26L800W
Xdriver[122] vss vss vdd vdd wl_n[122] wl[122] SP6T2WLDriver_N26L400WP26L800W
Xdriver[123] vss vss vdd vdd wl_n[123] wl[123] SP6T2WLDriver_N26L400WP26L800W
Xdriver[124] vss vss vdd vdd wl_n[124] wl[124] SP6T2WLDriver_N26L400WP26L800W
Xdriver[125] vss vss vdd vdd wl_n[125] wl[125] SP6T2WLDriver_N26L400WP26L800W
Xdriver[126] vss vss vdd vdd wl_n[126] wl[126] SP6T2WLDriver_N26L400WP26L800W
Xdriver[127] vss vss vdd vdd wl_n[127] wl[127] SP6T2WLDriver_N26L400WP26L800W
Xbc[0] vss vdd SP6T2WLDriverBC_N26L400WP26L800W
Xbc[1] vss vdd SP6T2WLDriverBC_N26L400WP26L800W
Xbc[2] vss vdd SP6T2WLDriverBC_N26L400WP26L800W
Xbc[3] vss vdd SP6T2WLDriverBC_N26L400WP26L800W
Xbc[4] vss vdd SP6T2WLDriverBC_N26L400WP26L800W
Xbc[5] vss vdd SP6T2WLDriverBC_N26L400WP26L800W
Xbc[6] vss vdd SP6T2WLDriverBC_N26L400WP26L800W
Xbc[7] vss vdd SP6T2WLDriverBC_N26L400WP26L800W
Xbc[8] vss vdd SP6T2WLDriverBC_N26L400WP26L800W
.ends SP6T2WLDriverCol_128RN26L400WP26L800W

.subckt SP6T2NonOvlClock_4S11341D1R vss vdd clk firststage[0] firststage[1] firststage[2] firststage[3] firststage[4] secondstage[0] secondstage[1] secondstage[2] secondstage[3] secondstage[4]
Xclkinv vdd vss clk clk_n inv_x0
Xfirstnand2 vdd vss firststage[0] clk secondstage[4] nand2_x0
Xfirststage[0] vdd vss firststage[0] firststage[1] inv_x0
Xfirststage[1] vdd vss firststage[1] firststage[2] inv_x0
Xfirststage[2] vdd vss firststage[2] firststage[3] inv_x0
Xfirststage[3] vdd vss firststage[3] firststage[4] inv_x0
Xsecondnand2 vdd vss secondstage[0] clk_n firststage[4] nand2_x0
Xsecondstage[0] vdd vss secondstage[0] secondstage[1] inv_x0
Xsecondstage[1] vdd vss secondstage[1] secondstage[2] inv_x0
Xsecondstage[2] vdd vss secondstage[2] secondstage[3] inv_x0
Xsecondstage[3] vdd vss secondstage[3] secondstage[4] inv_x0
.ends SP6T2NonOvlClock_4S11341D1R

.subckt SP6T2ClockGen_4S11341D1R vss vdd clk wl_en decodeclk columnclk precharge_n we_en
Xnonovl vss vdd clk firststage[0] firststage[1] firststage[2] firstpulse firststage[4] secondstage[0] secondstage[1] secondstage[2] secondpulse secondstage[4] SP6T2NonOvlClock_4S11341D1R
Xdecodeclkbuf vdd vss clk decodeclk buf_x1
Xcolumnclkbuf vdd vss clk columnclk buf_x1
Xprechargeinv vdd vss secondpulse precharge_n inv_x3
Xwlenbuf vdd vss firstpulse wl_en buf_x4
Xweenbuf vdd vss firstpulse we_en buf_x1
.ends SP6T2ClockGen_4S11341D1R

.subckt SP6T2DirectColDec_A2B2R vss vdd clk a[0] a[1] line[0] line[1] line[2] line[3]
Xaff[0] vdd vss a[0] clk aint[0] SP6T1Dec_dff_x1
Xaff[1] vdd vss a[1] clk aint[1] SP6T1Dec_dff_x1
Xainv[0] vdd vss aint[0] aint_n[0] SP6T1Dec_inv_x1
Xainv[1] vdd vss aint[1] aint_n[1] SP6T1Dec_inv_x1
Xlinenand[0] vdd vss line_n[0] aint_n[0] aint_n[1] SP6T1Dec_nand2_x0
Xlinenand[1] vdd vss line_n[1] aint[0] aint_n[1] SP6T1Dec_nand2_x0
Xlinenand[2] vdd vss line_n[2] aint_n[0] aint[1] SP6T1Dec_nand2_x0
Xlinenand[3] vdd vss line_n[3] aint[0] aint[1] SP6T1Dec_nand2_x0
Xlineinv[0] vdd vss line_n[0] line[0] SP6T1Dec_inv_x2
Xlineinv[1] vdd vss line_n[1] line[1] SP6T1Dec_inv_x2
Xlineinv[2] vdd vss line_n[2] line[2] SP6T1Dec_inv_x2
Xlineinv[3] vdd vss line_n[3] line[3] SP6T1Dec_inv_x2
.ends SP6T2DirectColDec_A2B2R

.subckt SP6T2RowPredecoders_A3B4B vss vdd clk a[0] a[1] a[2] a[3] a[4] a[5] a[6] pd[0][0] pd[0][1] pd[0][2] pd[0][3] pd[0][4] pd[0][5] pd[0][6] pd[0][7] page[0] page[1] page[2] page[3] page[4] page[5] page[6] page[7] page[8] page[9] page[10] page[11] page[12] page[13] page[14] page[15]
Xaff[0] vdd vss a[0] clk aint[0] SP6T1Dec_dff_x1
Xaff[1] vdd vss a[1] clk aint[1] SP6T1Dec_dff_x1
Xaff[2] vdd vss a[2] clk aint[2] SP6T1Dec_dff_x1
Xaff[3] vdd vss a[3] clk aint[3] SP6T1Dec_dff_x1
Xaff[4] vdd vss a[4] clk aint[4] SP6T1Dec_dff_x1
Xaff[5] vdd vss a[5] clk aint[5] SP6T1Dec_dff_x1
Xaff[6] vdd vss a[6] clk aint[6] SP6T1Dec_dff_x1
Xainv[0] vdd vss aint[0] aint_n[0] SP6T1Dec_inv_x1
Xainv[1] vdd vss aint[1] aint_n[1] SP6T1Dec_inv_x1
Xainv[2] vdd vss aint[2] aint_n[2] SP6T1Dec_inv_x1
Xainv[3] vdd vss aint[3] aint_n[3] SP6T1Dec_inv_x1
Xainv[4] vdd vss aint[4] aint_n[4] SP6T1Dec_inv_x1
Xainv[5] vdd vss aint[5] aint_n[5] SP6T1Dec_inv_x1
Xainv[6] vdd vss aint[6] aint_n[6] SP6T1Dec_inv_x1
Xpd[0]and[0] vdd vss pd[0][0] aint_n[0] aint_n[1] aint_n[2] SP6T1Dec_and3_x1
Xpd[0]and[1] vdd vss pd[0][1] aint[0] aint_n[1] aint_n[2] SP6T1Dec_and3_x1
Xpd[0]and[2] vdd vss pd[0][2] aint_n[0] aint[1] aint_n[2] SP6T1Dec_and3_x1
Xpd[0]and[3] vdd vss pd[0][3] aint[0] aint[1] aint_n[2] SP6T1Dec_and3_x1
Xpd[0]and[4] vdd vss pd[0][4] aint_n[0] aint_n[1] aint[2] SP6T1Dec_and3_x1
Xpd[0]and[5] vdd vss pd[0][5] aint[0] aint_n[1] aint[2] SP6T1Dec_and3_x1
Xpd[0]and[6] vdd vss pd[0][6] aint_n[0] aint[1] aint[2] SP6T1Dec_and3_x1
Xpd[0]and[7] vdd vss pd[0][7] aint[0] aint[1] aint[2] SP6T1Dec_and3_x1
Xpage_and[0] vdd vss page[0] aint_n[3] aint_n[4] aint_n[5] aint_n[6] SP6T1Dec_and4_x1
Xpage_and[1] vdd vss page[1] aint[3] aint_n[4] aint_n[5] aint_n[6] SP6T1Dec_and4_x1
Xpage_and[2] vdd vss page[2] aint_n[3] aint[4] aint_n[5] aint_n[6] SP6T1Dec_and4_x1
Xpage_and[3] vdd vss page[3] aint[3] aint[4] aint_n[5] aint_n[6] SP6T1Dec_and4_x1
Xpage_and[4] vdd vss page[4] aint_n[3] aint_n[4] aint[5] aint_n[6] SP6T1Dec_and4_x1
Xpage_and[5] vdd vss page[5] aint[3] aint_n[4] aint[5] aint_n[6] SP6T1Dec_and4_x1
Xpage_and[6] vdd vss page[6] aint_n[3] aint[4] aint[5] aint_n[6] SP6T1Dec_and4_x1
Xpage_and[7] vdd vss page[7] aint[3] aint[4] aint[5] aint_n[6] SP6T1Dec_and4_x1
Xpage_and[8] vdd vss page[8] aint_n[3] aint_n[4] aint_n[5] aint[6] SP6T1Dec_and4_x1
Xpage_and[9] vdd vss page[9] aint[3] aint_n[4] aint_n[5] aint[6] SP6T1Dec_and4_x1
Xpage_and[10] vdd vss page[10] aint_n[3] aint[4] aint_n[5] aint[6] SP6T1Dec_and4_x1
Xpage_and[11] vdd vss page[11] aint[3] aint[4] aint_n[5] aint[6] SP6T1Dec_and4_x1
Xpage_and[12] vdd vss page[12] aint_n[3] aint_n[4] aint[5] aint[6] SP6T1Dec_and4_x1
Xpage_and[13] vdd vss page[13] aint[3] aint_n[4] aint[5] aint[6] SP6T1Dec_and4_x1
Xpage_and[14] vdd vss page[14] aint_n[3] aint[4] aint[5] aint[6] SP6T1Dec_and4_x1
Xpage_and[15] vdd vss page[15] aint[3] aint[4] aint[5] aint[6] SP6T1Dec_and4_x1
Xtie[0] vdd vss SP6T1Dec_tie_diff_w4
Xtie[1] vdd vss SP6T1Dec_tie_diff_w4
Xtie[2] vdd vss SP6T1Dec_tie_diff_w4
Xtie[3] vdd vss SP6T1Dec_tie_diff_w4
Xtie[4] vdd vss SP6T1Dec_tie_diff_w4
Xtie[5] vdd vss SP6T1Dec_tie_diff_w4
Xtie[6] vdd vss SP6T1Dec_tie_diff_w4
Xtie[7] vdd vss SP6T1Dec_tie_diff_w4
Xtie[8] vdd vss SP6T1Dec_tie_diff_w4
Xtie[9] vdd vss SP6T1Dec_tie_diff_w4
Xtie[10] vdd vss SP6T1Dec_tie_diff_w4
Xtie[11] vdd vss SP6T1Dec_tie_diff_w4
Xtie[12] vdd vss SP6T1Dec_tie_diff_w4
Xtie[13] vdd vss SP6T1Dec_tie_diff_w4
Xtie[14] vdd vss SP6T1Dec_tie_diff_w4
Xtie[15] vdd vss SP6T1Dec_tie_diff_w4
Xtie[16] vdd vss SP6T1Dec_tie_diff_w4
Xtie[17] vdd vss SP6T1Dec_tie_diff_w4
Xtie[18] vdd vss SP6T1Dec_tie_diff_w4
Xtie[19] vdd vss SP6T1Dec_tie_diff_w4
Xtie[20] vdd vss SP6T1Dec_tie_diff_w4
Xtie[21] vdd vss SP6T1Dec_tie_diff_w4
Xtie[22] vdd vss SP6T1Dec_tie_diff_w4
Xtie[23] vdd vss SP6T1Dec_tie_diff_w4
Xtie[24] vdd vss SP6T1Dec_tie_diff_w4
Xtie[25] vdd vss SP6T1Dec_tie_diff_w4
Xtie[25] vdd vss SP6T1Dec_tie_diff_w4
Xtie[25] vdd vss SP6T1Dec_tie_diff_w4
Xtie[25] vdd vss SP6T1Dec_tie_diff_w4
Xtie[25] vdd vss SP6T1Dec_tie_diff_w4
Xtie[25] vdd vss SP6T1Dec_tie_diff_w4
Xtie[25] vdd vss SP6T1Dec_tie_diff_w4
Xtie[25] vdd vss SP6T1Dec_tie_diff_w4
Xtie[25] vdd vss SP6T1Dec_tie_diff_w4
Xtie[25] vdd vss SP6T1Dec_tie_diff_w4
Xtie[25] vdd vss SP6T1Dec_tie_diff_w4
Xtie[25] vdd vss SP6T1Dec_tie_diff_w4
Xtie[25] vdd vss SP6T1Dec_tie_diff_w4
Xtie[25] vdd vss SP6T1Dec_tie_diff_w4
Xtie[25] vdd vss SP6T1Dec_tie_diff_w4
Xtie[25] vdd vss SP6T1Dec_tie_diff_w4
Xtie[25] vdd vss SP6T1Dec_tie_diff_w4
Xtie[25] vdd vss SP6T1Dec_tie_diff_w4
Xtie[25] vdd vss SP6T1Dec_tie_diff_w4
Xtie[25] vdd vss SP6T1Dec_tie_diff_w4
Xtie[25] vdd vss SP6T1Dec_tie_diff_w4
Xtie[25] vdd vss SP6T1Dec_tie_diff_w4
.ends SP6T2RowPredecoders_A3B4B

.subckt SP6T2RowDecoderNand3X2 vss vdd pd[0][0] pd[0][1] page wl_en wl_n[0] wl_n[1]
Xnmos[0] wl_n[0] wl_en int[0] vss sg13_lv_nmos l=1.3e-07 w=4.9e-07
Xnmos[1] int[0] pd[0][0] int[1] vss sg13_lv_nmos l=1.3e-07 w=4.9e-07
Xnmos[2] int[1] page vss vss sg13_lv_nmos l=1.3e-07 w=4.9e-07
Xnmos[3] vss page int[2] vss sg13_lv_nmos l=1.3e-07 w=4.9e-07
Xnmos[4] int[2] pd[0][1] int[3] vss sg13_lv_nmos l=1.3e-07 w=4.9e-07
Xnmos[5] int[3] wl_en wl_n[1] vss sg13_lv_nmos l=1.3e-07 w=4.9e-07
Xpmos[0] wl_n[0] wl_en vdd vdd sg13_lv_pmos l=1.3e-07 w=4.9e-07
Xpmos[1] vdd pd[0][0] wl_n[0] vdd sg13_lv_pmos l=1.3e-07 w=4.9e-07
Xpmos[2] wl_n[0] page vdd vdd sg13_lv_pmos l=1.3e-07 w=4.9e-07
Xpmos[3] vdd page wl_n[1] vdd sg13_lv_pmos l=1.3e-07 w=4.9e-07
Xpmos[4] wl_n[1] pd[0][1] vdd vdd sg13_lv_pmos l=1.3e-07 w=4.9e-07
Xpmos[5] vdd wl_en wl_n[1] vdd sg13_lv_pmos l=1.3e-07 w=4.9e-07
.ends SP6T2RowDecoderNand3X2

.subckt SP6T2RowDecPage_PD3B4BDH vss vdd pd[0][0] pd[0][1] wl_n[0] wl_n[1] pd[0][2] pd[0][3] wl_n[2] wl_n[3] pd[0][4] pd[0][5] wl_n[4] wl_n[5] pd[0][6] pd[0][7] wl_n[6] wl_n[7] page wl_en
Xnand3[0] vss vdd pd[0][0] pd[0][1] page wl_en wl_n[0] wl_n[1] SP6T2RowDecoderNand3X2
Xnand3[1] vss vdd pd[0][2] pd[0][3] page wl_en wl_n[2] wl_n[3] SP6T2RowDecoderNand3X2
Xnand3[2] vss vdd pd[0][4] pd[0][5] page wl_en wl_n[4] wl_n[5] SP6T2RowDecoderNand3X2
Xnand3[3] vss vdd pd[0][6] pd[0][7] page wl_en wl_n[6] wl_n[7] SP6T2RowDecoderNand3X2
.ends SP6T2RowDecPage_PD3B4BDH

.subckt SP6T2RowDecLastStageBC_N3DH vss vdd
.ends SP6T2RowDecLastStageBC_N3DH

.subckt SP6T2RowDec_PD3B4B_PAG3B4B0 vss vdd a[0] a[1] a[2] a[3] a[4] a[5] a[6] clk wl_en wl_n[0] wl_n[1] wl_n[2] wl_n[3] wl_n[4] wl_n[5] wl_n[6] wl_n[7] wl_n[8] wl_n[9] wl_n[10] wl_n[11] wl_n[12] wl_n[13] wl_n[14] wl_n[15] wl_n[16] wl_n[17] wl_n[18] wl_n[19] wl_n[20] wl_n[21] wl_n[22] wl_n[23] wl_n[24] wl_n[25] wl_n[26] wl_n[27] wl_n[28] wl_n[29] wl_n[30] wl_n[31] wl_n[32] wl_n[33] wl_n[34] wl_n[35] wl_n[36] wl_n[37] wl_n[38] wl_n[39] wl_n[40] wl_n[41] wl_n[42] wl_n[43] wl_n[44] wl_n[45] wl_n[46] wl_n[47] wl_n[48] wl_n[49] wl_n[50] wl_n[51] wl_n[52] wl_n[53] wl_n[54] wl_n[55] wl_n[56] wl_n[57] wl_n[58] wl_n[59] wl_n[60] wl_n[61] wl_n[62] wl_n[63] wl_n[64] wl_n[65] wl_n[66] wl_n[67] wl_n[68] wl_n[69] wl_n[70] wl_n[71] wl_n[72] wl_n[73] wl_n[74] wl_n[75] wl_n[76] wl_n[77] wl_n[78] wl_n[79] wl_n[80] wl_n[81] wl_n[82] wl_n[83] wl_n[84] wl_n[85] wl_n[86] wl_n[87] wl_n[88] wl_n[89] wl_n[90] wl_n[91] wl_n[92] wl_n[93] wl_n[94] wl_n[95] wl_n[96] wl_n[97] wl_n[98] wl_n[99] wl_n[100] wl_n[101] wl_n[102] wl_n[103] wl_n[104] wl_n[105] wl_n[106] wl_n[107] wl_n[108] wl_n[109] wl_n[110] wl_n[111] wl_n[112] wl_n[113] wl_n[114] wl_n[115] wl_n[116] wl_n[117] wl_n[118] wl_n[119] wl_n[120] wl_n[121] wl_n[122] wl_n[123] wl_n[124] wl_n[125] wl_n[126] wl_n[127]
Xpredec vss vdd clk a[0] a[1] a[2] a[3] a[4] a[5] a[6] pd[0][0] pd[0][1] pd[0][2] pd[0][3] pd[0][4] pd[0][5] pd[0][6] pd[0][7] page[0] page[1] page[2] page[3] page[4] page[5] page[6] page[7] page[8] page[9] page[10] page[11] page[12] page[13] page[14] page[15] SP6T2RowPredecoders_A3B4B
Xpage[0] vss vdd pd[0][0] pd[0][1] wl_n[0] wl_n[1] pd[0][2] pd[0][3] wl_n[2] wl_n[3] pd[0][4] pd[0][5] wl_n[4] wl_n[5] pd[0][6] pd[0][7] wl_n[6] wl_n[7] page[0] wl_en SP6T2RowDecPage_PD3B4BDH
Xpage[1] vss vdd pd[0][0] pd[0][1] wl_n[8] wl_n[9] pd[0][2] pd[0][3] wl_n[10] wl_n[11] pd[0][4] pd[0][5] wl_n[12] wl_n[13] pd[0][6] pd[0][7] wl_n[14] wl_n[15] page[1] wl_en SP6T2RowDecPage_PD3B4BDH
Xpage[2] vss vdd pd[0][0] pd[0][1] wl_n[16] wl_n[17] pd[0][2] pd[0][3] wl_n[18] wl_n[19] pd[0][4] pd[0][5] wl_n[20] wl_n[21] pd[0][6] pd[0][7] wl_n[22] wl_n[23] page[2] wl_en SP6T2RowDecPage_PD3B4BDH
Xpage[3] vss vdd pd[0][0] pd[0][1] wl_n[24] wl_n[25] pd[0][2] pd[0][3] wl_n[26] wl_n[27] pd[0][4] pd[0][5] wl_n[28] wl_n[29] pd[0][6] pd[0][7] wl_n[30] wl_n[31] page[3] wl_en SP6T2RowDecPage_PD3B4BDH
Xpage[4] vss vdd pd[0][0] pd[0][1] wl_n[32] wl_n[33] pd[0][2] pd[0][3] wl_n[34] wl_n[35] pd[0][4] pd[0][5] wl_n[36] wl_n[37] pd[0][6] pd[0][7] wl_n[38] wl_n[39] page[4] wl_en SP6T2RowDecPage_PD3B4BDH
Xpage[5] vss vdd pd[0][0] pd[0][1] wl_n[40] wl_n[41] pd[0][2] pd[0][3] wl_n[42] wl_n[43] pd[0][4] pd[0][5] wl_n[44] wl_n[45] pd[0][6] pd[0][7] wl_n[46] wl_n[47] page[5] wl_en SP6T2RowDecPage_PD3B4BDH
Xpage[6] vss vdd pd[0][0] pd[0][1] wl_n[48] wl_n[49] pd[0][2] pd[0][3] wl_n[50] wl_n[51] pd[0][4] pd[0][5] wl_n[52] wl_n[53] pd[0][6] pd[0][7] wl_n[54] wl_n[55] page[6] wl_en SP6T2RowDecPage_PD3B4BDH
Xpage[7] vss vdd pd[0][0] pd[0][1] wl_n[56] wl_n[57] pd[0][2] pd[0][3] wl_n[58] wl_n[59] pd[0][4] pd[0][5] wl_n[60] wl_n[61] pd[0][6] pd[0][7] wl_n[62] wl_n[63] page[7] wl_en SP6T2RowDecPage_PD3B4BDH
Xpage[8] vss vdd pd[0][0] pd[0][1] wl_n[64] wl_n[65] pd[0][2] pd[0][3] wl_n[66] wl_n[67] pd[0][4] pd[0][5] wl_n[68] wl_n[69] pd[0][6] pd[0][7] wl_n[70] wl_n[71] page[8] wl_en SP6T2RowDecPage_PD3B4BDH
Xpage[9] vss vdd pd[0][0] pd[0][1] wl_n[72] wl_n[73] pd[0][2] pd[0][3] wl_n[74] wl_n[75] pd[0][4] pd[0][5] wl_n[76] wl_n[77] pd[0][6] pd[0][7] wl_n[78] wl_n[79] page[9] wl_en SP6T2RowDecPage_PD3B4BDH
Xpage[10] vss vdd pd[0][0] pd[0][1] wl_n[80] wl_n[81] pd[0][2] pd[0][3] wl_n[82] wl_n[83] pd[0][4] pd[0][5] wl_n[84] wl_n[85] pd[0][6] pd[0][7] wl_n[86] wl_n[87] page[10] wl_en SP6T2RowDecPage_PD3B4BDH
Xpage[11] vss vdd pd[0][0] pd[0][1] wl_n[88] wl_n[89] pd[0][2] pd[0][3] wl_n[90] wl_n[91] pd[0][4] pd[0][5] wl_n[92] wl_n[93] pd[0][6] pd[0][7] wl_n[94] wl_n[95] page[11] wl_en SP6T2RowDecPage_PD3B4BDH
Xpage[12] vss vdd pd[0][0] pd[0][1] wl_n[96] wl_n[97] pd[0][2] pd[0][3] wl_n[98] wl_n[99] pd[0][4] pd[0][5] wl_n[100] wl_n[101] pd[0][6] pd[0][7] wl_n[102] wl_n[103] page[12] wl_en SP6T2RowDecPage_PD3B4BDH
Xpage[13] vss vdd pd[0][0] pd[0][1] wl_n[104] wl_n[105] pd[0][2] pd[0][3] wl_n[106] wl_n[107] pd[0][4] pd[0][5] wl_n[108] wl_n[109] pd[0][6] pd[0][7] wl_n[110] wl_n[111] page[13] wl_en SP6T2RowDecPage_PD3B4BDH
Xpage[14] vss vdd pd[0][0] pd[0][1] wl_n[112] wl_n[113] pd[0][2] pd[0][3] wl_n[114] wl_n[115] pd[0][4] pd[0][5] wl_n[116] wl_n[117] pd[0][6] pd[0][7] wl_n[118] wl_n[119] page[14] wl_en SP6T2RowDecPage_PD3B4BDH
Xpage[15] vss vdd pd[0][0] pd[0][1] wl_n[120] wl_n[121] pd[0][2] pd[0][3] wl_n[122] wl_n[123] pd[0][4] pd[0][5] wl_n[124] wl_n[125] pd[0][6] pd[0][7] wl_n[126] wl_n[127] page[15] wl_en SP6T2RowDecPage_PD3B4BDH
Xbulkcon[0] vss vdd SP6T2RowDecLastStageBC_N3DH
Xbulkcon[1] vss vdd SP6T2RowDecLastStageBC_N3DH
Xbulkcon[2] vss vdd SP6T2RowDecLastStageBC_N3DH
Xbulkcon[3] vss vdd SP6T2RowDecLastStageBC_N3DH
Xbulkcon[4] vss vdd SP6T2RowDecLastStageBC_N3DH
Xbulkcon[5] vss vdd SP6T2RowDecLastStageBC_N3DH
Xbulkcon[6] vss vdd SP6T2RowDecLastStageBC_N3DH
Xbulkcon[7] vss vdd SP6T2RowDecLastStageBC_N3DH
Xbulkcon[8] vss vdd SP6T2RowDecLastStageBC_N3DH
.ends SP6T2RowDec_PD3B4B_PAG3B4B0

.subckt SP6T2RowPeriph_PD3B4B_LD2B2R vss vdd a[0] a[1] a[2] a[3] a[4] a[5] a[6] a[7] a[8] wl_n[0] wl_n[1] wl_n[2] wl_n[3] wl_n[4] wl_n[5] wl_n[6] wl_n[7] wl_n[8] wl_n[9] wl_n[10] wl_n[11] wl_n[12] wl_n[13] wl_n[14] wl_n[15] wl_n[16] wl_n[17] wl_n[18] wl_n[19] wl_n[20] wl_n[21] wl_n[22] wl_n[23] wl_n[24] wl_n[25] wl_n[26] wl_n[27] wl_n[28] wl_n[29] wl_n[30] wl_n[31] wl_n[32] wl_n[33] wl_n[34] wl_n[35] wl_n[36] wl_n[37] wl_n[38] wl_n[39] wl_n[40] wl_n[41] wl_n[42] wl_n[43] wl_n[44] wl_n[45] wl_n[46] wl_n[47] wl_n[48] wl_n[49] wl_n[50] wl_n[51] wl_n[52] wl_n[53] wl_n[54] wl_n[55] wl_n[56] wl_n[57] wl_n[58] wl_n[59] wl_n[60] wl_n[61] wl_n[62] wl_n[63] wl_n[64] wl_n[65] wl_n[66] wl_n[67] wl_n[68] wl_n[69] wl_n[70] wl_n[71] wl_n[72] wl_n[73] wl_n[74] wl_n[75] wl_n[76] wl_n[77] wl_n[78] wl_n[79] wl_n[80] wl_n[81] wl_n[82] wl_n[83] wl_n[84] wl_n[85] wl_n[86] wl_n[87] wl_n[88] wl_n[89] wl_n[90] wl_n[91] wl_n[92] wl_n[93] wl_n[94] wl_n[95] wl_n[96] wl_n[97] wl_n[98] wl_n[99] wl_n[100] wl_n[101] wl_n[102] wl_n[103] wl_n[104] wl_n[105] wl_n[106] wl_n[107] wl_n[108] wl_n[109] wl_n[110] wl_n[111] wl_n[112] wl_n[113] wl_n[114] wl_n[115] wl_n[116] wl_n[117] wl_n[118] wl_n[119] wl_n[120] wl_n[121] wl_n[122] wl_n[123] wl_n[124] wl_n[125] wl_n[126] wl_n[127] decodeclk wl_en mux[0] mux[1] mux[2] mux[3]
Xcoldec vss vdd decodeclk a[0] a[1] mux[0] mux[1] mux[2] mux[3] SP6T2DirectColDec_A2B2R
Xrowdec vss vdd a[2] a[3] a[4] a[5] a[6] a[7] a[8] decodeclk wl_en wl_n[0] wl_n[1] wl_n[2] wl_n[3] wl_n[4] wl_n[5] wl_n[6] wl_n[7] wl_n[8] wl_n[9] wl_n[10] wl_n[11] wl_n[12] wl_n[13] wl_n[14] wl_n[15] wl_n[16] wl_n[17] wl_n[18] wl_n[19] wl_n[20] wl_n[21] wl_n[22] wl_n[23] wl_n[24] wl_n[25] wl_n[26] wl_n[27] wl_n[28] wl_n[29] wl_n[30] wl_n[31] wl_n[32] wl_n[33] wl_n[34] wl_n[35] wl_n[36] wl_n[37] wl_n[38] wl_n[39] wl_n[40] wl_n[41] wl_n[42] wl_n[43] wl_n[44] wl_n[45] wl_n[46] wl_n[47] wl_n[48] wl_n[49] wl_n[50] wl_n[51] wl_n[52] wl_n[53] wl_n[54] wl_n[55] wl_n[56] wl_n[57] wl_n[58] wl_n[59] wl_n[60] wl_n[61] wl_n[62] wl_n[63] wl_n[64] wl_n[65] wl_n[66] wl_n[67] wl_n[68] wl_n[69] wl_n[70] wl_n[71] wl_n[72] wl_n[73] wl_n[74] wl_n[75] wl_n[76] wl_n[77] wl_n[78] wl_n[79] wl_n[80] wl_n[81] wl_n[82] wl_n[83] wl_n[84] wl_n[85] wl_n[86] wl_n[87] wl_n[88] wl_n[89] wl_n[90] wl_n[91] wl_n[92] wl_n[93] wl_n[94] wl_n[95] wl_n[96] wl_n[97] wl_n[98] wl_n[99] wl_n[100] wl_n[101] wl_n[102] wl_n[103] wl_n[104] wl_n[105] wl_n[106] wl_n[107] wl_n[108] wl_n[109] wl_n[110] wl_n[111] wl_n[112] wl_n[113] wl_n[114] wl_n[115] wl_n[116] wl_n[117] wl_n[118] wl_n[119] wl_n[120] wl_n[121] wl_n[122] wl_n[123] wl_n[124] wl_n[125] wl_n[126] wl_n[127] SP6T2RowDec_PD3B4B_PAG3B4B0
.ends SP6T2RowPeriph_PD3B4B_LD2B2R

.subckt SP6T2Block_512x32_4we_C2B_R3B4B clk a[0] a[1] a[2] a[3] a[4] a[5] a[6] a[7] a[8] vss vdd q[0] q[1] q[2] q[3] q[4] q[5] q[6] q[7] q[8] q[9] q[10] q[11] q[12] q[13] q[14] q[15] q[16] q[17] q[18] q[19] q[20] q[21] q[22] q[23] q[24] q[25] q[26] q[27] q[28] q[29] q[30] q[31] d[0] d[1] d[2] d[3] d[4] d[5] d[6] d[7] d[8] d[9] d[10] d[11] d[12] d[13] d[14] d[15] d[16] d[17] d[18] d[19] d[20] d[21] d[22] d[23] d[24] d[25] d[26] d[27] d[28] d[29] d[30] d[31] we[0] we[1] we[2] we[3]
Xcolumnblock vss vdd columnclk precharge_n we_en wl[0] wl[1] wl[2] wl[3] wl[4] wl[5] wl[6] wl[7] wl[8] wl[9] wl[10] wl[11] wl[12] wl[13] wl[14] wl[15] wl[16] wl[17] wl[18] wl[19] wl[20] wl[21] wl[22] wl[23] wl[24] wl[25] wl[26] wl[27] wl[28] wl[29] wl[30] wl[31] wl[32] wl[33] wl[34] wl[35] wl[36] wl[37] wl[38] wl[39] wl[40] wl[41] wl[42] wl[43] wl[44] wl[45] wl[46] wl[47] wl[48] wl[49] wl[50] wl[51] wl[52] wl[53] wl[54] wl[55] wl[56] wl[57] wl[58] wl[59] wl[60] wl[61] wl[62] wl[63] wl[64] wl[65] wl[66] wl[67] wl[68] wl[69] wl[70] wl[71] wl[72] wl[73] wl[74] wl[75] wl[76] wl[77] wl[78] wl[79] wl[80] wl[81] wl[82] wl[83] wl[84] wl[85] wl[86] wl[87] wl[88] wl[89] wl[90] wl[91] wl[92] wl[93] wl[94] wl[95] wl[96] wl[97] wl[98] wl[99] wl[100] wl[101] wl[102] wl[103] wl[104] wl[105] wl[106] wl[107] wl[108] wl[109] wl[110] wl[111] wl[112] wl[113] wl[114] wl[115] wl[116] wl[117] wl[118] wl[119] wl[120] wl[121] wl[122] wl[123] wl[124] wl[125] wl[126] wl[127] mux[0] mux[1] mux[2] mux[3] we[0] q[0] d[0] q[1] d[1] q[2] d[2] q[3] d[3] q[4] d[4] q[5] d[5] q[6] d[6] q[7] d[7] we[1] q[8] d[8] q[9] d[9] q[10] d[10] q[11] d[11] q[12] d[12] q[13] d[13] q[14] d[14] q[15] d[15] we[2] q[16] d[16] q[17] d[17] q[18] d[18] q[19] d[19] q[20] d[20] q[21] d[21] q[22] d[22] q[23] d[23] we[3] q[24] d[24] q[25] d[25] q[26] d[26] q[27] d[27] q[28] d[28] q[29] d[29] q[30] d[30] q[31] d[31] SP6T2ColumnBlock_COL128R_CP8B_CM4MN26L580W1R_PC26L100W_4WE
Xwldrivercol vss vdd wl[0] wl_n[0] wl[1] wl_n[1] wl[2] wl_n[2] wl[3] wl_n[3] wl[4] wl_n[4] wl[5] wl_n[5] wl[6] wl_n[6] wl[7] wl_n[7] wl[8] wl_n[8] wl[9] wl_n[9] wl[10] wl_n[10] wl[11] wl_n[11] wl[12] wl_n[12] wl[13] wl_n[13] wl[14] wl_n[14] wl[15] wl_n[15] wl[16] wl_n[16] wl[17] wl_n[17] wl[18] wl_n[18] wl[19] wl_n[19] wl[20] wl_n[20] wl[21] wl_n[21] wl[22] wl_n[22] wl[23] wl_n[23] wl[24] wl_n[24] wl[25] wl_n[25] wl[26] wl_n[26] wl[27] wl_n[27] wl[28] wl_n[28] wl[29] wl_n[29] wl[30] wl_n[30] wl[31] wl_n[31] wl[32] wl_n[32] wl[33] wl_n[33] wl[34] wl_n[34] wl[35] wl_n[35] wl[36] wl_n[36] wl[37] wl_n[37] wl[38] wl_n[38] wl[39] wl_n[39] wl[40] wl_n[40] wl[41] wl_n[41] wl[42] wl_n[42] wl[43] wl_n[43] wl[44] wl_n[44] wl[45] wl_n[45] wl[46] wl_n[46] wl[47] wl_n[47] wl[48] wl_n[48] wl[49] wl_n[49] wl[50] wl_n[50] wl[51] wl_n[51] wl[52] wl_n[52] wl[53] wl_n[53] wl[54] wl_n[54] wl[55] wl_n[55] wl[56] wl_n[56] wl[57] wl_n[57] wl[58] wl_n[58] wl[59] wl_n[59] wl[60] wl_n[60] wl[61] wl_n[61] wl[62] wl_n[62] wl[63] wl_n[63] wl[64] wl_n[64] wl[65] wl_n[65] wl[66] wl_n[66] wl[67] wl_n[67] wl[68] wl_n[68] wl[69] wl_n[69] wl[70] wl_n[70] wl[71] wl_n[71] wl[72] wl_n[72] wl[73] wl_n[73] wl[74] wl_n[74] wl[75] wl_n[75] wl[76] wl_n[76] wl[77] wl_n[77] wl[78] wl_n[78] wl[79] wl_n[79] wl[80] wl_n[80] wl[81] wl_n[81] wl[82] wl_n[82] wl[83] wl_n[83] wl[84] wl_n[84] wl[85] wl_n[85] wl[86] wl_n[86] wl[87] wl_n[87] wl[88] wl_n[88] wl[89] wl_n[89] wl[90] wl_n[90] wl[91] wl_n[91] wl[92] wl_n[92] wl[93] wl_n[93] wl[94] wl_n[94] wl[95] wl_n[95] wl[96] wl_n[96] wl[97] wl_n[97] wl[98] wl_n[98] wl[99] wl_n[99] wl[100] wl_n[100] wl[101] wl_n[101] wl[102] wl_n[102] wl[103] wl_n[103] wl[104] wl_n[104] wl[105] wl_n[105] wl[106] wl_n[106] wl[107] wl_n[107] wl[108] wl_n[108] wl[109] wl_n[109] wl[110] wl_n[110] wl[111] wl_n[111] wl[112] wl_n[112] wl[113] wl_n[113] wl[114] wl_n[114] wl[115] wl_n[115] wl[116] wl_n[116] wl[117] wl_n[117] wl[118] wl_n[118] wl[119] wl_n[119] wl[120] wl_n[120] wl[121] wl_n[121] wl[122] wl_n[122] wl[123] wl_n[123] wl[124] wl_n[124] wl[125] wl_n[125] wl[126] wl_n[126] wl[127] wl_n[127] SP6T2WLDriverCol_128RN26L400WP26L800W
Xclkgen vss vdd clk wl_en decodeclk columnclk precharge_n we_en SP6T2ClockGen_4S11341D1R
Xrowperiph vss vdd a[0] a[1] a[2] a[3] a[4] a[5] a[6] a[7] a[8] wl_n[0] wl_n[1] wl_n[2] wl_n[3] wl_n[4] wl_n[5] wl_n[6] wl_n[7] wl_n[8] wl_n[9] wl_n[10] wl_n[11] wl_n[12] wl_n[13] wl_n[14] wl_n[15] wl_n[16] wl_n[17] wl_n[18] wl_n[19] wl_n[20] wl_n[21] wl_n[22] wl_n[23] wl_n[24] wl_n[25] wl_n[26] wl_n[27] wl_n[28] wl_n[29] wl_n[30] wl_n[31] wl_n[32] wl_n[33] wl_n[34] wl_n[35] wl_n[36] wl_n[37] wl_n[38] wl_n[39] wl_n[40] wl_n[41] wl_n[42] wl_n[43] wl_n[44] wl_n[45] wl_n[46] wl_n[47] wl_n[48] wl_n[49] wl_n[50] wl_n[51] wl_n[52] wl_n[53] wl_n[54] wl_n[55] wl_n[56] wl_n[57] wl_n[58] wl_n[59] wl_n[60] wl_n[61] wl_n[62] wl_n[63] wl_n[64] wl_n[65] wl_n[66] wl_n[67] wl_n[68] wl_n[69] wl_n[70] wl_n[71] wl_n[72] wl_n[73] wl_n[74] wl_n[75] wl_n[76] wl_n[77] wl_n[78] wl_n[79] wl_n[80] wl_n[81] wl_n[82] wl_n[83] wl_n[84] wl_n[85] wl_n[86] wl_n[87] wl_n[88] wl_n[89] wl_n[90] wl_n[91] wl_n[92] wl_n[93] wl_n[94] wl_n[95] wl_n[96] wl_n[97] wl_n[98] wl_n[99] wl_n[100] wl_n[101] wl_n[102] wl_n[103] wl_n[104] wl_n[105] wl_n[106] wl_n[107] wl_n[108] wl_n[109] wl_n[110] wl_n[111] wl_n[112] wl_n[113] wl_n[114] wl_n[115] wl_n[116] wl_n[117] wl_n[118] wl_n[119] wl_n[120] wl_n[121] wl_n[122] wl_n[123] wl_n[124] wl_n[125] wl_n[126] wl_n[127] decodeclk wl_en mux[0] mux[1] mux[2] mux[3] SP6T2RowPeriph_PD3B4B_LD2B2R
.ends SP6T2Block_512x32_4we_C2B_R3B4B

.subckt SP6T2TimingIn_9SF vss vdd sr_in sr_out sr_shift sr_latch i[8] i[7] i[6] i[5] i[4] i[3] i[2] i[1] i[0]
Xshiftff[8] vdd vss sr_in sr_shift i_s[8] dff_x1
Xshiftff[7] vdd vss i_s[8] sr_shift i_s[7] dff_x1
Xshiftff[6] vdd vss i_s[7] sr_shift i_s[6] dff_x1
Xshiftff[5] vdd vss i_s[6] sr_shift i_s[5] dff_x1
Xshiftff[4] vdd vss i_s[5] sr_shift i_s[4] dff_x1
Xshiftff[3] vdd vss i_s[4] sr_shift i_s[3] dff_x1
Xshiftff[2] vdd vss i_s[3] sr_shift i_s[2] dff_x1
Xshiftff[1] vdd vss i_s[2] sr_shift i_s[1] dff_x1
Xshiftff[0] vdd vss i_s[1] sr_shift sr_out dff_x1
Xlatchff[8] vdd vss i_s[8] sr_latch i[8] dff_x1
Xlatchff[7] vdd vss i_s[7] sr_latch i[7] dff_x1
Xlatchff[6] vdd vss i_s[6] sr_latch i[6] dff_x1
Xlatchff[5] vdd vss i_s[5] sr_latch i[5] dff_x1
Xlatchff[4] vdd vss i_s[4] sr_latch i[4] dff_x1
Xlatchff[3] vdd vss i_s[3] sr_latch i[3] dff_x1
Xlatchff[2] vdd vss i_s[2] sr_latch i[2] dff_x1
Xlatchff[1] vdd vss i_s[1] sr_latch i[1] dff_x1
Xlatchff[0] vdd vss sr_out sr_latch i[0] dff_x1
.ends SP6T2TimingIn_9SF

.subckt SP6T2TimingOut_2SL vss vdd sr_in sr_out sr_shift sr_latch l2s o[0] o[1]
Xshiftff[0] vdd vss o_m[0] sr_shift o_s[0] dff_x1
Xshiftff[1] vdd vss o_m[1] sr_shift sr_out dff_x1
Xlatchff[0] vdd vss o[0] sr_latch o_l[0] dff_x1
Xlatchff[1] vdd vss o[1] sr_latch o_l[1] dff_x1
Xmux[0] vdd vss sr_in o_l[0] l2s o_m[0] mux2_x1
Xmux[1] vdd vss o_s[0] o_l[1] l2s o_m[1] mux2_x1
.ends SP6T2TimingOut_2SL

.subckt SP6T2TimingIn_9SL vss vdd sr_in sr_out sr_shift sr_latch i[0] i[1] i[2] i[3] i[4] i[5] i[6] i[7] i[8]
Xshiftff[0] vdd vss sr_in sr_shift i_s[0] dff_x1
Xshiftff[1] vdd vss i_s[0] sr_shift i_s[1] dff_x1
Xshiftff[2] vdd vss i_s[1] sr_shift i_s[2] dff_x1
Xshiftff[3] vdd vss i_s[2] sr_shift i_s[3] dff_x1
Xshiftff[4] vdd vss i_s[3] sr_shift i_s[4] dff_x1
Xshiftff[5] vdd vss i_s[4] sr_shift i_s[5] dff_x1
Xshiftff[6] vdd vss i_s[5] sr_shift i_s[6] dff_x1
Xshiftff[7] vdd vss i_s[6] sr_shift i_s[7] dff_x1
Xshiftff[8] vdd vss i_s[7] sr_shift sr_out dff_x1
Xlatchff[0] vdd vss i_s[0] sr_latch i[0] dff_x1
Xlatchff[1] vdd vss i_s[1] sr_latch i[1] dff_x1
Xlatchff[2] vdd vss i_s[2] sr_latch i[2] dff_x1
Xlatchff[3] vdd vss i_s[3] sr_latch i[3] dff_x1
Xlatchff[4] vdd vss i_s[4] sr_latch i[4] dff_x1
Xlatchff[5] vdd vss i_s[5] sr_latch i[5] dff_x1
Xlatchff[6] vdd vss i_s[6] sr_latch i[6] dff_x1
Xlatchff[7] vdd vss i_s[7] sr_latch i[7] dff_x1
Xlatchff[8] vdd vss sr_out sr_latch i[8] dff_x1
.ends SP6T2TimingIn_9SL

.subckt SP6T2TimingOut_8SL vss vdd sr_in sr_out sr_shift sr_latch l2s o[0] o[1] o[2] o[3] o[4] o[5] o[6] o[7]
Xshiftff[0] vdd vss o_m[0] sr_shift o_s[0] dff_x1
Xshiftff[1] vdd vss o_m[1] sr_shift o_s[1] dff_x1
Xshiftff[2] vdd vss o_m[2] sr_shift o_s[2] dff_x1
Xshiftff[3] vdd vss o_m[3] sr_shift o_s[3] dff_x1
Xshiftff[4] vdd vss o_m[4] sr_shift o_s[4] dff_x1
Xshiftff[5] vdd vss o_m[5] sr_shift o_s[5] dff_x1
Xshiftff[6] vdd vss o_m[6] sr_shift o_s[6] dff_x1
Xshiftff[7] vdd vss o_m[7] sr_shift sr_out dff_x1
Xlatchff[0] vdd vss o[0] sr_latch o_l[0] dff_x1
Xlatchff[1] vdd vss o[1] sr_latch o_l[1] dff_x1
Xlatchff[2] vdd vss o[2] sr_latch o_l[2] dff_x1
Xlatchff[3] vdd vss o[3] sr_latch o_l[3] dff_x1
Xlatchff[4] vdd vss o[4] sr_latch o_l[4] dff_x1
Xlatchff[5] vdd vss o[5] sr_latch o_l[5] dff_x1
Xlatchff[6] vdd vss o[6] sr_latch o_l[6] dff_x1
Xlatchff[7] vdd vss o[7] sr_latch o_l[7] dff_x1
Xmux[0] vdd vss sr_in o_l[0] l2s o_m[0] mux2_x1
Xmux[1] vdd vss o_s[0] o_l[1] l2s o_m[1] mux2_x1
Xmux[2] vdd vss o_s[1] o_l[2] l2s o_m[2] mux2_x1
Xmux[3] vdd vss o_s[2] o_l[3] l2s o_m[3] mux2_x1
Xmux[4] vdd vss o_s[3] o_l[4] l2s o_m[4] mux2_x1
Xmux[5] vdd vss o_s[4] o_l[5] l2s o_m[5] mux2_x1
Xmux[6] vdd vss o_s[5] o_l[6] l2s o_m[6] mux2_x1
Xmux[7] vdd vss o_s[6] o_l[7] l2s o_m[7] mux2_x1
.ends SP6T2TimingOut_8SL

.subckt SP6T2Block_512x32_4we_C2B_R3B4B_Test vss vdd_block vdd_periph clk in_shift in_latch in_srin in_srout out_shift out_latch out_l2s out_srin out_srout
Xblock clk a[0] a[1] a[2] a[3] a[4] a[5] a[6] a[7] a[8] vss vdd_block q[0] q[1] q[2] q[3] q[4] q[5] q[6] q[7] q[8] q[9] q[10] q[11] q[12] q[13] q[14] q[15] q[16] q[17] q[18] q[19] q[20] q[21] q[22] q[23] q[24] q[25] q[26] q[27] q[28] q[29] q[30] q[31] d[0] d[1] d[2] d[3] d[4] d[5] d[6] d[7] d[8] d[9] d[10] d[11] d[12] d[13] d[14] d[15] d[16] d[17] d[18] d[19] d[20] d[21] d[22] d[23] d[24] d[25] d[26] d[27] d[28] d[29] d[30] d[31] we[0] we[1] we[2] we[3] SP6T2Block_512x32_4we_C2B_R3B4B
Xasr vss vdd_periph in_srin in_srconn[0] in_shift in_latch a[8] a[7] a[6] a[5] a[4] a[3] a[2] a[1] a[0] SP6T2TimingIn_9SF
Xclksr vss vdd_periph out_srin out_srconn[0] out_shift clk out_l2s in_latch out_latch SP6T2TimingOut_2SL
Xdwesr[0] vss vdd_periph in_srconn[0] in_srconn[1] in_shift in_latch d[0] d[1] d[2] d[3] d[4] d[5] d[6] d[7] we[0] SP6T2TimingIn_9SL
Xdwesr[1] vss vdd_periph in_srconn[1] in_srconn[2] in_shift in_latch d[8] d[9] d[10] d[11] d[12] d[13] d[14] d[15] we[1] SP6T2TimingIn_9SL
Xdwesr[2] vss vdd_periph in_srconn[2] in_srconn[3] in_shift in_latch d[16] d[17] d[18] d[19] d[20] d[21] d[22] d[23] we[2] SP6T2TimingIn_9SL
Xdwesr[3] vss vdd_periph in_srconn[3] in_srout in_shift in_latch d[24] d[25] d[26] d[27] d[28] d[29] d[30] d[31] we[3] SP6T2TimingIn_9SL
Xqsr[0] vss vdd_periph out_srconn[0] out_srconn[1] out_shift out_latch out_l2s q[0] q[1] q[2] q[3] q[4] q[5] q[6] q[7] SP6T2TimingOut_8SL
Xqsr[1] vss vdd_periph out_srconn[1] out_srconn[2] out_shift out_latch out_l2s q[8] q[9] q[10] q[11] q[12] q[13] q[14] q[15] SP6T2TimingOut_8SL
Xqsr[2] vss vdd_periph out_srconn[2] out_srconn[3] out_shift out_latch out_l2s q[16] q[17] q[18] q[19] q[20] q[21] q[22] q[23] SP6T2TimingOut_8SL
Xqsr[3] vss vdd_periph out_srconn[3] out_srout out_shift out_latch out_l2s q[24] q[25] q[26] q[27] q[28] q[29] q[30] q[31] SP6T2TimingOut_8SL
Xinsrin_antdio vdd_periph vss in_srin diode_w1
Xinshift_antdio vdd_periph vss in_shift diode_w1
Xinlatch_antdio vdd_periph vss in_latch diode_w1
Xfill[0] vdd_periph vss tie_w2
Xfill[1] vdd_periph vss tie_w2
Xoutlatch_antdio vdd_periph vss out_latch diode_w1
Xoutshift_antdio vdd_periph vss out_shift diode_w1
Xoutsrin_antdio vdd_periph vss out_srin diode_w1
Xoutl2s_antdio vdd_periph vss out_l2s diode_w1
Xclk_antdio vdd_periph vss clk diode_w1
Xfill[2] vdd_periph vss tie_w2
Xfill[3] vdd_periph vss tie_w2
.ends SP6T2Block_512x32_4we_C2B_R3B4B_Test

.subckt PadFrame_SP02 PAD0x0 PAD0x1 PAD0x2 PAD0x3 PAD0x4 PAD0x5 PAD0x6 PAD0x7 PAD0x8 PAD0x9 PAD1x0 PAD1x1 PAD1x2 PAD1x3 PAD1x4 PAD1x5 PAD1x6 PAD1x7 PAD1x8 PAD1x9
XPAD0x0 PAD0x0 BondPad
XPAD0x1 PAD0x1 BondPad
XPAD0x2 PAD0x2 BondPad
XPAD0x3 PAD0x3 BondPad
XPAD0x4 PAD0x4 BondPad
XPAD0x5 PAD0x5 BondPad
XPAD0x6 PAD0x6 BondPad
XPAD0x7 PAD0x7 BondPad
XPAD0x8 PAD0x8 BondPad
XPAD0x9 PAD0x9 BondPad
XPAD1x0 PAD1x0 BondPad
XPAD1x1 PAD1x1 BondPad
XPAD1x2 PAD1x2 BondPad
XPAD1x3 PAD1x3 BondPad
XPAD1x4 PAD1x4 BondPad
XPAD1x5 PAD1x5 BondPad
XPAD1x6 PAD1x6 BondPad
XPAD1x7 PAD1x7 BondPad
XPAD1x8 PAD1x8 BondPad
XPAD1x9 PAD1x9 BondPad
.ends PadFrame_SP02

.subckt SP02 vss vdd_periph vdd_block in_srout out_srout clk out_latch out_shift out_l2s out_srin in_shift in_srin in_latch
Xtestblock vss vdd_block vdd_periph clk in_shift in_latch in_srin in_srout out_shift out_latch out_l2s out_srin out_srout SP6T2Block_512x32_4we_C2B_R3B4B_Test
Xpadframe vdd_block vss clk out_shift out_srin in_srin in_latch noconn noconn noconn vdd_periph in_srout out_srout out_latch out_l2s in_shift noconn noconn noconn noconn PadFrame_SP02
.ends SP02

.subckt sp6t2_io clk in_srin in_latch in_shift out_srin out_latch out_shift out_l2s in_srout out_srout vdd_block
Xmem vss vdd_block_int vdd clk_int in_shift_int in_latch_int in_srin_int in_srout_int out_shift_int out_latch_int out_l2s_int out_srin_int out_srout_int SP6T2Block_512x32_4we_C2B_R3B4B_Test
Xclk_bp clk BondPad
Xclk_io clk clk_int sg13g2_IOPadIn
Xin_srin_bp in_srin BondPad
Xin_srin_io in_srin in_srin_int sg13g2_IOPadIn
Xin_latch_bp in_latch BondPad
Xin_latch_io in_latch in_latch_int sg13g2_IOPadIn
Xin_shift_bp in_shift BondPad
Xin_shift_io in_shift in_shift_int sg13g2_IOPadIn
Xout_srin_bp out_srin BondPad
Xout_srin_io out_srin out_srin_int sg13g2_IOPadIn
Xout_latch_bp out_latch BondPad
Xout_latch_io out_latch out_latch_int sg13g2_IOPadIn
Xout_shift_bp out_shift BondPad
Xout_shift_io out_shift out_shift_int sg13g2_IOPadIn
Xout_l2s_bp out_l2s BondPad
Xout_l2s_io out_l2s out_l2s_int sg13g2_IOPadIn
Xin_srout_bp in_srout BondPad
Xin_srout_io in_srout in_srout_int sg13g2_IOPadOut30mA
Xout_srout_bp out_srout BondPad
Xout_srout_io out_srout out_srout_int sg13g2_IOPadOut30mA
Xvdd_block_bp vdd_block BondPad
Xvdd_block_io vdd_block vdd_block_int sg13g2_IOPadAnalog
Xiofill0  sg13g2_Filler4000
Xiofill1  sg13g2_Filler4000
Xiofill2  sg13g2_Filler4000
Xiofill3  sg13g2_Filler4000
Xiofill4  sg13g2_Filler4000
Xiofill5  sg13g2_Filler4000
Xiofill6  sg13g2_Filler4000
Xiofill7  sg13g2_Filler4000
Xiofill8  sg13g2_Filler4000
Xiofill9  sg13g2_Filler4000
.ends sp6t2_io

.subckt SP6T3Cell vss substrate vdd nwell wl bl bl_n
Xpu1 vdd bit_n bit nwell sg13_lv_pmos l=1.3e-07 w=2e-07
Xpd1 bit bit_n vss substrate sg13_lv_nmos l=1.3e-07 w=9e-07
Xpu2 vdd bit bit_n nwell sg13_lv_pmos l=1.3e-07 w=2e-07
Xpd2 bit_n bit vss substrate sg13_lv_nmos l=1.3e-07 w=9e-07
Xpg1 bit wl bl substrate sg13_lv_nmos l=1.3e-07 w=2e-07
Xpg2 bit_n wl bl_n substrate sg13_lv_nmos l=1.3e-07 w=2e-07
.ends SP6T3Cell

.subckt SP6T3Array_2X1 vss substrate vdd nwell wl[0] wl[1] bl[0] bl_n[0]
Xinst0x0 vss substrate vdd nwell wl[0] bl[0] bl_n[0] SP6T3Cell
Xinst1x0 vss substrate vdd nwell wl[1] bl[0] bl_n[0] SP6T3Cell
.ends SP6T3Array_2X1

.subckt SP6T3Array_2X2 vss substrate vdd nwell wl[0] wl[1] bl[0] bl_n[0] bl[1] bl_n[1]
Xinst0x0 vss substrate vdd nwell wl[0] wl[1] bl[0] bl_n[0] SP6T3Array_2X1
Xinst0x1 vss substrate vdd nwell wl[0] wl[1] bl[1] bl_n[1] SP6T3Array_2X1
.ends SP6T3Array_2X2

.subckt SP6T3Array_4X2 vss substrate vdd nwell wl[0] wl[1] wl[2] wl[3] bl[0] bl_n[0] bl[1] bl_n[1]
Xinst0x0 vss substrate vdd nwell wl[0] wl[1] bl[0] bl_n[0] bl[1] bl_n[1] SP6T3Array_2X2
Xinst1x0 vss substrate vdd nwell wl[2] wl[3] bl[0] bl_n[0] bl[1] bl_n[1] SP6T3Array_2X2
.ends SP6T3Array_4X2

.subckt SP6T3Array_4X4 vss substrate vdd nwell wl[0] wl[1] wl[2] wl[3] bl[0] bl_n[0] bl[1] bl_n[1] bl[2] bl_n[2] bl[3] bl_n[3]
Xinst0x0 vss substrate vdd nwell wl[0] wl[1] wl[2] wl[3] bl[0] bl_n[0] bl[1] bl_n[1] SP6T3Array_4X2
Xinst0x1 vss substrate vdd nwell wl[0] wl[1] wl[2] wl[3] bl[2] bl_n[2] bl[3] bl_n[3] SP6T3Array_4X2
.ends SP6T3Array_4X4

.subckt SP6T3Array_8X4 vss substrate vdd nwell wl[0] wl[1] wl[2] wl[3] wl[4] wl[5] wl[6] wl[7] bl[0] bl_n[0] bl[1] bl_n[1] bl[2] bl_n[2] bl[3] bl_n[3]
Xinst0x0 vss substrate vdd nwell wl[0] wl[1] wl[2] wl[3] bl[0] bl_n[0] bl[1] bl_n[1] bl[2] bl_n[2] bl[3] bl_n[3] SP6T3Array_4X4
Xinst1x0 vss substrate vdd nwell wl[4] wl[5] wl[6] wl[7] bl[0] bl_n[0] bl[1] bl_n[1] bl[2] bl_n[2] bl[3] bl_n[3] SP6T3Array_4X4
.ends SP6T3Array_8X4

.subckt SP6T3Array_8X8 vss substrate vdd nwell wl[0] wl[1] wl[2] wl[3] wl[4] wl[5] wl[6] wl[7] bl[0] bl_n[0] bl[1] bl_n[1] bl[2] bl_n[2] bl[3] bl_n[3] bl[4] bl_n[4] bl[5] bl_n[5] bl[6] bl_n[6] bl[7] bl_n[7]
Xinst0x0 vss substrate vdd nwell wl[0] wl[1] wl[2] wl[3] wl[4] wl[5] wl[6] wl[7] bl[0] bl_n[0] bl[1] bl_n[1] bl[2] bl_n[2] bl[3] bl_n[3] SP6T3Array_8X4
Xinst0x1 vss substrate vdd nwell wl[0] wl[1] wl[2] wl[3] wl[4] wl[5] wl[6] wl[7] bl[4] bl_n[4] bl[5] bl_n[5] bl[6] bl_n[6] bl[7] bl_n[7] SP6T3Array_8X4
.ends SP6T3Array_8X8

.subckt SP6T3Array_16X8 vss substrate vdd nwell wl[0] wl[1] wl[2] wl[3] wl[4] wl[5] wl[6] wl[7] wl[8] wl[9] wl[10] wl[11] wl[12] wl[13] wl[14] wl[15] bl[0] bl_n[0] bl[1] bl_n[1] bl[2] bl_n[2] bl[3] bl_n[3] bl[4] bl_n[4] bl[5] bl_n[5] bl[6] bl_n[6] bl[7] bl_n[7]
Xinst0x0 vss substrate vdd nwell wl[0] wl[1] wl[2] wl[3] wl[4] wl[5] wl[6] wl[7] bl[0] bl_n[0] bl[1] bl_n[1] bl[2] bl_n[2] bl[3] bl_n[3] bl[4] bl_n[4] bl[5] bl_n[5] bl[6] bl_n[6] bl[7] bl_n[7] SP6T3Array_8X8
Xinst1x0 vss substrate vdd nwell wl[8] wl[9] wl[10] wl[11] wl[12] wl[13] wl[14] wl[15] bl[0] bl_n[0] bl[1] bl_n[1] bl[2] bl_n[2] bl[3] bl_n[3] bl[4] bl_n[4] bl[5] bl_n[5] bl[6] bl_n[6] bl[7] bl_n[7] SP6T3Array_8X8
.ends SP6T3Array_16X8

.subckt SP6T3Array_16X16 vss substrate vdd nwell wl[0] wl[1] wl[2] wl[3] wl[4] wl[5] wl[6] wl[7] wl[8] wl[9] wl[10] wl[11] wl[12] wl[13] wl[14] wl[15] bl[0] bl_n[0] bl[1] bl_n[1] bl[2] bl_n[2] bl[3] bl_n[3] bl[4] bl_n[4] bl[5] bl_n[5] bl[6] bl_n[6] bl[7] bl_n[7] bl[8] bl_n[8] bl[9] bl_n[9] bl[10] bl_n[10] bl[11] bl_n[11] bl[12] bl_n[12] bl[13] bl_n[13] bl[14] bl_n[14] bl[15] bl_n[15]
Xinst0x0 vss substrate vdd nwell wl[0] wl[1] wl[2] wl[3] wl[4] wl[5] wl[6] wl[7] wl[8] wl[9] wl[10] wl[11] wl[12] wl[13] wl[14] wl[15] bl[0] bl_n[0] bl[1] bl_n[1] bl[2] bl_n[2] bl[3] bl_n[3] bl[4] bl_n[4] bl[5] bl_n[5] bl[6] bl_n[6] bl[7] bl_n[7] SP6T3Array_16X8
Xinst0x1 vss substrate vdd nwell wl[0] wl[1] wl[2] wl[3] wl[4] wl[5] wl[6] wl[7] wl[8] wl[9] wl[10] wl[11] wl[12] wl[13] wl[14] wl[15] bl[8] bl_n[8] bl[9] bl_n[9] bl[10] bl_n[10] bl[11] bl_n[11] bl[12] bl_n[12] bl[13] bl_n[13] bl[14] bl_n[14] bl[15] bl_n[15] SP6T3Array_16X8
.ends SP6T3Array_16X16

.subckt SP6T3Array_16X32 vss substrate vdd nwell wl[0] wl[1] wl[2] wl[3] wl[4] wl[5] wl[6] wl[7] wl[8] wl[9] wl[10] wl[11] wl[12] wl[13] wl[14] wl[15] bl[0] bl_n[0] bl[1] bl_n[1] bl[2] bl_n[2] bl[3] bl_n[3] bl[4] bl_n[4] bl[5] bl_n[5] bl[6] bl_n[6] bl[7] bl_n[7] bl[8] bl_n[8] bl[9] bl_n[9] bl[10] bl_n[10] bl[11] bl_n[11] bl[12] bl_n[12] bl[13] bl_n[13] bl[14] bl_n[14] bl[15] bl_n[15] bl[16] bl_n[16] bl[17] bl_n[17] bl[18] bl_n[18] bl[19] bl_n[19] bl[20] bl_n[20] bl[21] bl_n[21] bl[22] bl_n[22] bl[23] bl_n[23] bl[24] bl_n[24] bl[25] bl_n[25] bl[26] bl_n[26] bl[27] bl_n[27] bl[28] bl_n[28] bl[29] bl_n[29] bl[30] bl_n[30] bl[31] bl_n[31]
Xinst0x0 vss substrate vdd nwell wl[0] wl[1] wl[2] wl[3] wl[4] wl[5] wl[6] wl[7] wl[8] wl[9] wl[10] wl[11] wl[12] wl[13] wl[14] wl[15] bl[0] bl_n[0] bl[1] bl_n[1] bl[2] bl_n[2] bl[3] bl_n[3] bl[4] bl_n[4] bl[5] bl_n[5] bl[6] bl_n[6] bl[7] bl_n[7] bl[8] bl_n[8] bl[9] bl_n[9] bl[10] bl_n[10] bl[11] bl_n[11] bl[12] bl_n[12] bl[13] bl_n[13] bl[14] bl_n[14] bl[15] bl_n[15] SP6T3Array_16X16
Xinst0x1 vss substrate vdd nwell wl[0] wl[1] wl[2] wl[3] wl[4] wl[5] wl[6] wl[7] wl[8] wl[9] wl[10] wl[11] wl[12] wl[13] wl[14] wl[15] bl[16] bl_n[16] bl[17] bl_n[17] bl[18] bl_n[18] bl[19] bl_n[19] bl[20] bl_n[20] bl[21] bl_n[21] bl[22] bl_n[22] bl[23] bl_n[23] bl[24] bl_n[24] bl[25] bl_n[25] bl[26] bl_n[26] bl[27] bl_n[27] bl[28] bl_n[28] bl[29] bl_n[29] bl[30] bl_n[30] bl[31] bl_n[31] SP6T3Array_16X16
.ends SP6T3Array_16X32

.subckt SP6T3BulkConn vdd vss bl bl_n
.ends SP6T3BulkConn

.subckt SP6T3BulkConnRow_2C vss vdd bl[0] bl_n[0] bl[1] bl_n[1]
Xinst0 vdd vss bl[0] bl_n[0] SP6T3BulkConn
Xinst1 vdd vss bl[1] bl_n[1] SP6T3BulkConn
.ends SP6T3BulkConnRow_2C

.subckt SP6T3BulkConnRow_4C vss vdd bl[0] bl_n[0] bl[1] bl_n[1] bl[2] bl_n[2] bl[3] bl_n[3]
Xinst0 vss vdd bl[0] bl_n[0] bl[1] bl_n[1] SP6T3BulkConnRow_2C
Xinst1 vss vdd bl[2] bl_n[2] bl[3] bl_n[3] SP6T3BulkConnRow_2C
.ends SP6T3BulkConnRow_4C

.subckt SP6T3BulkConnRow_8C vss vdd bl[0] bl_n[0] bl[1] bl_n[1] bl[2] bl_n[2] bl[3] bl_n[3] bl[4] bl_n[4] bl[5] bl_n[5] bl[6] bl_n[6] bl[7] bl_n[7]
Xinst0 vss vdd bl[0] bl_n[0] bl[1] bl_n[1] bl[2] bl_n[2] bl[3] bl_n[3] SP6T3BulkConnRow_4C
Xinst1 vss vdd bl[4] bl_n[4] bl[5] bl_n[5] bl[6] bl_n[6] bl[7] bl_n[7] SP6T3BulkConnRow_4C
.ends SP6T3BulkConnRow_8C

.subckt SP6T3BulkConnRow_16C vss vdd bl[0] bl_n[0] bl[1] bl_n[1] bl[2] bl_n[2] bl[3] bl_n[3] bl[4] bl_n[4] bl[5] bl_n[5] bl[6] bl_n[6] bl[7] bl_n[7] bl[8] bl_n[8] bl[9] bl_n[9] bl[10] bl_n[10] bl[11] bl_n[11] bl[12] bl_n[12] bl[13] bl_n[13] bl[14] bl_n[14] bl[15] bl_n[15]
Xinst0 vss vdd bl[0] bl_n[0] bl[1] bl_n[1] bl[2] bl_n[2] bl[3] bl_n[3] bl[4] bl_n[4] bl[5] bl_n[5] bl[6] bl_n[6] bl[7] bl_n[7] SP6T3BulkConnRow_8C
Xinst1 vss vdd bl[8] bl_n[8] bl[9] bl_n[9] bl[10] bl_n[10] bl[11] bl_n[11] bl[12] bl_n[12] bl[13] bl_n[13] bl[14] bl_n[14] bl[15] bl_n[15] SP6T3BulkConnRow_8C
.ends SP6T3BulkConnRow_16C

.subckt SP6T3BulkConnRow_32C vss vdd bl[0] bl_n[0] bl[1] bl_n[1] bl[2] bl_n[2] bl[3] bl_n[3] bl[4] bl_n[4] bl[5] bl_n[5] bl[6] bl_n[6] bl[7] bl_n[7] bl[8] bl_n[8] bl[9] bl_n[9] bl[10] bl_n[10] bl[11] bl_n[11] bl[12] bl_n[12] bl[13] bl_n[13] bl[14] bl_n[14] bl[15] bl_n[15] bl[16] bl_n[16] bl[17] bl_n[17] bl[18] bl_n[18] bl[19] bl_n[19] bl[20] bl_n[20] bl[21] bl_n[21] bl[22] bl_n[22] bl[23] bl_n[23] bl[24] bl_n[24] bl[25] bl_n[25] bl[26] bl_n[26] bl[27] bl_n[27] bl[28] bl_n[28] bl[29] bl_n[29] bl[30] bl_n[30] bl[31] bl_n[31]
Xinst0 vss vdd bl[0] bl_n[0] bl[1] bl_n[1] bl[2] bl_n[2] bl[3] bl_n[3] bl[4] bl_n[4] bl[5] bl_n[5] bl[6] bl_n[6] bl[7] bl_n[7] bl[8] bl_n[8] bl[9] bl_n[9] bl[10] bl_n[10] bl[11] bl_n[11] bl[12] bl_n[12] bl[13] bl_n[13] bl[14] bl_n[14] bl[15] bl_n[15] SP6T3BulkConnRow_16C
Xinst1 vss vdd bl[16] bl_n[16] bl[17] bl_n[17] bl[18] bl_n[18] bl[19] bl_n[19] bl[20] bl_n[20] bl[21] bl_n[21] bl[22] bl_n[22] bl[23] bl_n[23] bl[24] bl_n[24] bl[25] bl_n[25] bl[26] bl_n[26] bl[27] bl_n[27] bl[28] bl_n[28] bl[29] bl_n[29] bl[30] bl_n[30] bl[31] bl_n[31] SP6T3BulkConnRow_16C
.ends SP6T3BulkConnRow_32C

.subckt SP6T3Array_32X32 vss vdd wl[0] wl[1] wl[2] wl[3] wl[4] wl[5] wl[6] wl[7] wl[8] wl[9] wl[10] wl[11] wl[12] wl[13] wl[14] wl[15] wl[16] wl[17] wl[18] wl[19] wl[20] wl[21] wl[22] wl[23] wl[24] wl[25] wl[26] wl[27] wl[28] wl[29] wl[30] wl[31] bl[0] bl_n[0] bl[1] bl_n[1] bl[2] bl_n[2] bl[3] bl_n[3] bl[4] bl_n[4] bl[5] bl_n[5] bl[6] bl_n[6] bl[7] bl_n[7] bl[8] bl_n[8] bl[9] bl_n[9] bl[10] bl_n[10] bl[11] bl_n[11] bl[12] bl_n[12] bl[13] bl_n[13] bl[14] bl_n[14] bl[15] bl_n[15] bl[16] bl_n[16] bl[17] bl_n[17] bl[18] bl_n[18] bl[19] bl_n[19] bl[20] bl_n[20] bl[21] bl_n[21] bl[22] bl_n[22] bl[23] bl_n[23] bl[24] bl_n[24] bl[25] bl_n[25] bl[26] bl_n[26] bl[27] bl_n[27] bl[28] bl_n[28] bl[29] bl_n[29] bl[30] bl_n[30] bl[31] bl_n[31]
Xinst0x0 vss vss vdd vdd wl[0] wl[1] wl[2] wl[3] wl[4] wl[5] wl[6] wl[7] wl[8] wl[9] wl[10] wl[11] wl[12] wl[13] wl[14] wl[15] bl[0] bl_n[0] bl[1] bl_n[1] bl[2] bl_n[2] bl[3] bl_n[3] bl[4] bl_n[4] bl[5] bl_n[5] bl[6] bl_n[6] bl[7] bl_n[7] bl[8] bl_n[8] bl[9] bl_n[9] bl[10] bl_n[10] bl[11] bl_n[11] bl[12] bl_n[12] bl[13] bl_n[13] bl[14] bl_n[14] bl[15] bl_n[15] bl[16] bl_n[16] bl[17] bl_n[17] bl[18] bl_n[18] bl[19] bl_n[19] bl[20] bl_n[20] bl[21] bl_n[21] bl[22] bl_n[22] bl[23] bl_n[23] bl[24] bl_n[24] bl[25] bl_n[25] bl[26] bl_n[26] bl[27] bl_n[27] bl[28] bl_n[28] bl[29] bl_n[29] bl[30] bl_n[30] bl[31] bl_n[31] SP6T3Array_16X32
Xinst1x0 vss vss vdd vdd wl[16] wl[17] wl[18] wl[19] wl[20] wl[21] wl[22] wl[23] wl[24] wl[25] wl[26] wl[27] wl[28] wl[29] wl[30] wl[31] bl[0] bl_n[0] bl[1] bl_n[1] bl[2] bl_n[2] bl[3] bl_n[3] bl[4] bl_n[4] bl[5] bl_n[5] bl[6] bl_n[6] bl[7] bl_n[7] bl[8] bl_n[8] bl[9] bl_n[9] bl[10] bl_n[10] bl[11] bl_n[11] bl[12] bl_n[12] bl[13] bl_n[13] bl[14] bl_n[14] bl[15] bl_n[15] bl[16] bl_n[16] bl[17] bl_n[17] bl[18] bl_n[18] bl[19] bl_n[19] bl[20] bl_n[20] bl[21] bl_n[21] bl[22] bl_n[22] bl[23] bl_n[23] bl[24] bl_n[24] bl[25] bl_n[25] bl[26] bl_n[26] bl[27] bl_n[27] bl[28] bl_n[28] bl[29] bl_n[29] bl[30] bl_n[30] bl[31] bl_n[31] SP6T3Array_16X32
Xbcrow vss vdd bl[0] bl_n[0] bl[1] bl_n[1] bl[2] bl_n[2] bl[3] bl_n[3] bl[4] bl_n[4] bl[5] bl_n[5] bl[6] bl_n[6] bl[7] bl_n[7] bl[8] bl_n[8] bl[9] bl_n[9] bl[10] bl_n[10] bl[11] bl_n[11] bl[12] bl_n[12] bl[13] bl_n[13] bl[14] bl_n[14] bl[15] bl_n[15] bl[16] bl_n[16] bl[17] bl_n[17] bl[18] bl_n[18] bl[19] bl_n[19] bl[20] bl_n[20] bl[21] bl_n[21] bl[22] bl_n[22] bl[23] bl_n[23] bl[24] bl_n[24] bl[25] bl_n[25] bl[26] bl_n[26] bl[27] bl_n[27] bl[28] bl_n[28] bl[29] bl_n[29] bl[30] bl_n[30] bl[31] bl_n[31] SP6T3BulkConnRow_32C
.ends SP6T3Array_32X32

.subckt SP6T3Array_64X32 vss vdd wl[0] wl[1] wl[2] wl[3] wl[4] wl[5] wl[6] wl[7] wl[8] wl[9] wl[10] wl[11] wl[12] wl[13] wl[14] wl[15] wl[16] wl[17] wl[18] wl[19] wl[20] wl[21] wl[22] wl[23] wl[24] wl[25] wl[26] wl[27] wl[28] wl[29] wl[30] wl[31] wl[32] wl[33] wl[34] wl[35] wl[36] wl[37] wl[38] wl[39] wl[40] wl[41] wl[42] wl[43] wl[44] wl[45] wl[46] wl[47] wl[48] wl[49] wl[50] wl[51] wl[52] wl[53] wl[54] wl[55] wl[56] wl[57] wl[58] wl[59] wl[60] wl[61] wl[62] wl[63] bl[0] bl_n[0] bl[1] bl_n[1] bl[2] bl_n[2] bl[3] bl_n[3] bl[4] bl_n[4] bl[5] bl_n[5] bl[6] bl_n[6] bl[7] bl_n[7] bl[8] bl_n[8] bl[9] bl_n[9] bl[10] bl_n[10] bl[11] bl_n[11] bl[12] bl_n[12] bl[13] bl_n[13] bl[14] bl_n[14] bl[15] bl_n[15] bl[16] bl_n[16] bl[17] bl_n[17] bl[18] bl_n[18] bl[19] bl_n[19] bl[20] bl_n[20] bl[21] bl_n[21] bl[22] bl_n[22] bl[23] bl_n[23] bl[24] bl_n[24] bl[25] bl_n[25] bl[26] bl_n[26] bl[27] bl_n[27] bl[28] bl_n[28] bl[29] bl_n[29] bl[30] bl_n[30] bl[31] bl_n[31]
Xinst0x0 vss vdd wl[0] wl[1] wl[2] wl[3] wl[4] wl[5] wl[6] wl[7] wl[8] wl[9] wl[10] wl[11] wl[12] wl[13] wl[14] wl[15] wl[16] wl[17] wl[18] wl[19] wl[20] wl[21] wl[22] wl[23] wl[24] wl[25] wl[26] wl[27] wl[28] wl[29] wl[30] wl[31] bl[0] bl_n[0] bl[1] bl_n[1] bl[2] bl_n[2] bl[3] bl_n[3] bl[4] bl_n[4] bl[5] bl_n[5] bl[6] bl_n[6] bl[7] bl_n[7] bl[8] bl_n[8] bl[9] bl_n[9] bl[10] bl_n[10] bl[11] bl_n[11] bl[12] bl_n[12] bl[13] bl_n[13] bl[14] bl_n[14] bl[15] bl_n[15] bl[16] bl_n[16] bl[17] bl_n[17] bl[18] bl_n[18] bl[19] bl_n[19] bl[20] bl_n[20] bl[21] bl_n[21] bl[22] bl_n[22] bl[23] bl_n[23] bl[24] bl_n[24] bl[25] bl_n[25] bl[26] bl_n[26] bl[27] bl_n[27] bl[28] bl_n[28] bl[29] bl_n[29] bl[30] bl_n[30] bl[31] bl_n[31] SP6T3Array_32X32
Xinst1x0 vss vdd wl[32] wl[33] wl[34] wl[35] wl[36] wl[37] wl[38] wl[39] wl[40] wl[41] wl[42] wl[43] wl[44] wl[45] wl[46] wl[47] wl[48] wl[49] wl[50] wl[51] wl[52] wl[53] wl[54] wl[55] wl[56] wl[57] wl[58] wl[59] wl[60] wl[61] wl[62] wl[63] bl[0] bl_n[0] bl[1] bl_n[1] bl[2] bl_n[2] bl[3] bl_n[3] bl[4] bl_n[4] bl[5] bl_n[5] bl[6] bl_n[6] bl[7] bl_n[7] bl[8] bl_n[8] bl[9] bl_n[9] bl[10] bl_n[10] bl[11] bl_n[11] bl[12] bl_n[12] bl[13] bl_n[13] bl[14] bl_n[14] bl[15] bl_n[15] bl[16] bl_n[16] bl[17] bl_n[17] bl[18] bl_n[18] bl[19] bl_n[19] bl[20] bl_n[20] bl[21] bl_n[21] bl[22] bl_n[22] bl[23] bl_n[23] bl[24] bl_n[24] bl[25] bl_n[25] bl[26] bl_n[26] bl[27] bl_n[27] bl[28] bl_n[28] bl[29] bl_n[29] bl[30] bl_n[30] bl[31] bl_n[31] SP6T3Array_32X32
Xbcrow vss vdd bl[0] bl_n[0] bl[1] bl_n[1] bl[2] bl_n[2] bl[3] bl_n[3] bl[4] bl_n[4] bl[5] bl_n[5] bl[6] bl_n[6] bl[7] bl_n[7] bl[8] bl_n[8] bl[9] bl_n[9] bl[10] bl_n[10] bl[11] bl_n[11] bl[12] bl_n[12] bl[13] bl_n[13] bl[14] bl_n[14] bl[15] bl_n[15] bl[16] bl_n[16] bl[17] bl_n[17] bl[18] bl_n[18] bl[19] bl_n[19] bl[20] bl_n[20] bl[21] bl_n[21] bl[22] bl_n[22] bl[23] bl_n[23] bl[24] bl_n[24] bl[25] bl_n[25] bl[26] bl_n[26] bl[27] bl_n[27] bl[28] bl_n[28] bl[29] bl_n[29] bl[30] bl_n[30] bl[31] bl_n[31] SP6T3BulkConnRow_32C
.ends SP6T3Array_64X32

.subckt SP6T3Array_128X32BC vss vdd wl[0] wl[1] wl[2] wl[3] wl[4] wl[5] wl[6] wl[7] wl[8] wl[9] wl[10] wl[11] wl[12] wl[13] wl[14] wl[15] wl[16] wl[17] wl[18] wl[19] wl[20] wl[21] wl[22] wl[23] wl[24] wl[25] wl[26] wl[27] wl[28] wl[29] wl[30] wl[31] wl[32] wl[33] wl[34] wl[35] wl[36] wl[37] wl[38] wl[39] wl[40] wl[41] wl[42] wl[43] wl[44] wl[45] wl[46] wl[47] wl[48] wl[49] wl[50] wl[51] wl[52] wl[53] wl[54] wl[55] wl[56] wl[57] wl[58] wl[59] wl[60] wl[61] wl[62] wl[63] wl[64] wl[65] wl[66] wl[67] wl[68] wl[69] wl[70] wl[71] wl[72] wl[73] wl[74] wl[75] wl[76] wl[77] wl[78] wl[79] wl[80] wl[81] wl[82] wl[83] wl[84] wl[85] wl[86] wl[87] wl[88] wl[89] wl[90] wl[91] wl[92] wl[93] wl[94] wl[95] wl[96] wl[97] wl[98] wl[99] wl[100] wl[101] wl[102] wl[103] wl[104] wl[105] wl[106] wl[107] wl[108] wl[109] wl[110] wl[111] wl[112] wl[113] wl[114] wl[115] wl[116] wl[117] wl[118] wl[119] wl[120] wl[121] wl[122] wl[123] wl[124] wl[125] wl[126] wl[127] bl[0] bl_n[0] bl[1] bl_n[1] bl[2] bl_n[2] bl[3] bl_n[3] bl[4] bl_n[4] bl[5] bl_n[5] bl[6] bl_n[6] bl[7] bl_n[7] bl[8] bl_n[8] bl[9] bl_n[9] bl[10] bl_n[10] bl[11] bl_n[11] bl[12] bl_n[12] bl[13] bl_n[13] bl[14] bl_n[14] bl[15] bl_n[15] bl[16] bl_n[16] bl[17] bl_n[17] bl[18] bl_n[18] bl[19] bl_n[19] bl[20] bl_n[20] bl[21] bl_n[21] bl[22] bl_n[22] bl[23] bl_n[23] bl[24] bl_n[24] bl[25] bl_n[25] bl[26] bl_n[26] bl[27] bl_n[27] bl[28] bl_n[28] bl[29] bl_n[29] bl[30] bl_n[30] bl[31] bl_n[31]
Xinst0x0 vss vdd wl[0] wl[1] wl[2] wl[3] wl[4] wl[5] wl[6] wl[7] wl[8] wl[9] wl[10] wl[11] wl[12] wl[13] wl[14] wl[15] wl[16] wl[17] wl[18] wl[19] wl[20] wl[21] wl[22] wl[23] wl[24] wl[25] wl[26] wl[27] wl[28] wl[29] wl[30] wl[31] wl[32] wl[33] wl[34] wl[35] wl[36] wl[37] wl[38] wl[39] wl[40] wl[41] wl[42] wl[43] wl[44] wl[45] wl[46] wl[47] wl[48] wl[49] wl[50] wl[51] wl[52] wl[53] wl[54] wl[55] wl[56] wl[57] wl[58] wl[59] wl[60] wl[61] wl[62] wl[63] bl[0] bl_n[0] bl[1] bl_n[1] bl[2] bl_n[2] bl[3] bl_n[3] bl[4] bl_n[4] bl[5] bl_n[5] bl[6] bl_n[6] bl[7] bl_n[7] bl[8] bl_n[8] bl[9] bl_n[9] bl[10] bl_n[10] bl[11] bl_n[11] bl[12] bl_n[12] bl[13] bl_n[13] bl[14] bl_n[14] bl[15] bl_n[15] bl[16] bl_n[16] bl[17] bl_n[17] bl[18] bl_n[18] bl[19] bl_n[19] bl[20] bl_n[20] bl[21] bl_n[21] bl[22] bl_n[22] bl[23] bl_n[23] bl[24] bl_n[24] bl[25] bl_n[25] bl[26] bl_n[26] bl[27] bl_n[27] bl[28] bl_n[28] bl[29] bl_n[29] bl[30] bl_n[30] bl[31] bl_n[31] SP6T3Array_64X32
Xinst1x0 vss vdd wl[64] wl[65] wl[66] wl[67] wl[68] wl[69] wl[70] wl[71] wl[72] wl[73] wl[74] wl[75] wl[76] wl[77] wl[78] wl[79] wl[80] wl[81] wl[82] wl[83] wl[84] wl[85] wl[86] wl[87] wl[88] wl[89] wl[90] wl[91] wl[92] wl[93] wl[94] wl[95] wl[96] wl[97] wl[98] wl[99] wl[100] wl[101] wl[102] wl[103] wl[104] wl[105] wl[106] wl[107] wl[108] wl[109] wl[110] wl[111] wl[112] wl[113] wl[114] wl[115] wl[116] wl[117] wl[118] wl[119] wl[120] wl[121] wl[122] wl[123] wl[124] wl[125] wl[126] wl[127] bl[0] bl_n[0] bl[1] bl_n[1] bl[2] bl_n[2] bl[3] bl_n[3] bl[4] bl_n[4] bl[5] bl_n[5] bl[6] bl_n[6] bl[7] bl_n[7] bl[8] bl_n[8] bl[9] bl_n[9] bl[10] bl_n[10] bl[11] bl_n[11] bl[12] bl_n[12] bl[13] bl_n[13] bl[14] bl_n[14] bl[15] bl_n[15] bl[16] bl_n[16] bl[17] bl_n[17] bl[18] bl_n[18] bl[19] bl_n[19] bl[20] bl_n[20] bl[21] bl_n[21] bl[22] bl_n[22] bl[23] bl_n[23] bl[24] bl_n[24] bl[25] bl_n[25] bl[26] bl_n[26] bl[27] bl_n[27] bl[28] bl_n[28] bl[29] bl_n[29] bl[30] bl_n[30] bl[31] bl_n[31] SP6T3Array_64X32
Xbcrow vss vdd bl[0] bl_n[0] bl[1] bl_n[1] bl[2] bl_n[2] bl[3] bl_n[3] bl[4] bl_n[4] bl[5] bl_n[5] bl[6] bl_n[6] bl[7] bl_n[7] bl[8] bl_n[8] bl[9] bl_n[9] bl[10] bl_n[10] bl[11] bl_n[11] bl[12] bl_n[12] bl[13] bl_n[13] bl[14] bl_n[14] bl[15] bl_n[15] bl[16] bl_n[16] bl[17] bl_n[17] bl[18] bl_n[18] bl[19] bl_n[19] bl[20] bl_n[20] bl[21] bl_n[21] bl[22] bl_n[22] bl[23] bl_n[23] bl[24] bl_n[24] bl[25] bl_n[25] bl[26] bl_n[26] bl[27] bl_n[27] bl[28] bl_n[28] bl[29] bl_n[29] bl[30] bl_n[30] bl[31] bl_n[31] SP6T3BulkConnRow_32C
Xbottombcrow vss vdd bl[0] bl_n[0] bl[1] bl_n[1] bl[2] bl_n[2] bl[3] bl_n[3] bl[4] bl_n[4] bl[5] bl_n[5] bl[6] bl_n[6] bl[7] bl_n[7] bl[8] bl_n[8] bl[9] bl_n[9] bl[10] bl_n[10] bl[11] bl_n[11] bl[12] bl_n[12] bl[13] bl_n[13] bl[14] bl_n[14] bl[15] bl_n[15] bl[16] bl_n[16] bl[17] bl_n[17] bl[18] bl_n[18] bl[19] bl_n[19] bl[20] bl_n[20] bl[21] bl_n[21] bl[22] bl_n[22] bl[23] bl_n[23] bl[24] bl_n[24] bl[25] bl_n[25] bl[26] bl_n[26] bl[27] bl_n[27] bl[28] bl_n[28] bl[29] bl_n[29] bl[30] bl_n[30] bl[31] bl_n[31] SP6T3BulkConnRow_32C
Xtopbcrow vss vdd bl[0] bl_n[0] bl[1] bl_n[1] bl[2] bl_n[2] bl[3] bl_n[3] bl[4] bl_n[4] bl[5] bl_n[5] bl[6] bl_n[6] bl[7] bl_n[7] bl[8] bl_n[8] bl[9] bl_n[9] bl[10] bl_n[10] bl[11] bl_n[11] bl[12] bl_n[12] bl[13] bl_n[13] bl[14] bl_n[14] bl[15] bl_n[15] bl[16] bl_n[16] bl[17] bl_n[17] bl[18] bl_n[18] bl[19] bl_n[19] bl[20] bl_n[20] bl[21] bl_n[21] bl[22] bl_n[22] bl[23] bl_n[23] bl[24] bl_n[24] bl[25] bl_n[25] bl[26] bl_n[26] bl[27] bl_n[27] bl[28] bl_n[28] bl[29] bl_n[29] bl[30] bl_n[30] bl[31] bl_n[31] SP6T3BulkConnRow_32C
.ends SP6T3Array_128X32BC

.subckt SP6T3Precharge_26L100W vdd nwell bl bl_n precharge_n
Xpc1 vdd precharge_n bl nwell sg13_lv_pmos l=1.3e-07 w=5e-07
Xpc2 bl precharge_n bl_n nwell sg13_lv_pmos l=1.3e-07 w=5e-07
Xpc3 bl_n precharge_n vdd nwell sg13_lv_pmos l=1.3e-07 w=5e-07
.ends SP6T3Precharge_26L100W

.subckt SP6T3ColMux_4MN26L580W1R bl[0] bl_n[0] mux[0] bl[1] bl_n[1] mux[1] bl[2] bl_n[2] mux[2] bl[3] bl_n[3] mux[3] vss muxbl muxbl_n
Xpgbl0 muxbl mux[0] bl[0] vss sg13_lv_nmos l=1.3e-07 w=2.9e-06
Xpgbln0 bl_n[0] mux[0] muxbl_n vss sg13_lv_nmos l=1.3e-07 w=2.9e-06
Xpgbl1 bl[1] mux[1] muxbl vss sg13_lv_nmos l=1.3e-07 w=2.9e-06
Xpgbln1 muxbl_n mux[1] bl_n[1] vss sg13_lv_nmos l=1.3e-07 w=2.9e-06
Xpgbl2 muxbl mux[2] bl[2] vss sg13_lv_nmos l=1.3e-07 w=2.9e-06
Xpgbln2 bl_n[2] mux[2] muxbl_n vss sg13_lv_nmos l=1.3e-07 w=2.9e-06
Xpgbl3 bl[3] mux[3] muxbl vss sg13_lv_nmos l=1.3e-07 w=2.9e-06
Xpgbln3 muxbl_n mux[3] bl_n[3] vss sg13_lv_nmos l=1.3e-07 w=2.9e-06
.ends SP6T3ColMux_4MN26L580W1R

.subckt SP6T3ReadWrite_CM4MN26L580W1R_WD26L380W vss vdd d q bl bl_n clk we_n
Xsenseamp vdd vss bl_n bl q noconn nsnrlatch_x1
Xd_ff vdd vss d clk d_l dff_x1
Xd_inv vdd vss d_l d_n inv_x0
Xnora vdd vss bl_pd_g d_l we_n nor2_x0
Xnorb vdd vss bln_pd_g d_n we_n nor2_x0
Xbl_pd bl bl_pd_g vss vss sg13_lv_nmos l=1.3e-07 w=1.9e-06
Xbln_pd vss bln_pd_g bl_n vss sg13_lv_nmos l=1.3e-07 w=1.9e-06
.ends SP6T3ReadWrite_CM4MN26L580W1R_WD26L380W

.subckt SP6T3ClockWE vss vdd clkup clkdown we we_en we_n
Xclkbuf vdd vss clkup clkdown buf_x2
Xweff vdd vss we clkdown we_l dff_x1
Xwenand vdd vss we_n we_l we_en nand2_x0
.ends SP6T3ClockWE

.subckt SP6T3ColPeriph8B_PC26L100W_CM4MN26L580W1R vss vdd nwell clk precharge_n we we_en q[0] d[0] bl[0] bl_n[0] bl[1] bl_n[1] bl[2] bl_n[2] bl[3] bl_n[3] q[1] d[1] bl[4] bl_n[4] bl[5] bl_n[5] bl[6] bl_n[6] bl[7] bl_n[7] q[2] d[2] bl[8] bl_n[8] bl[9] bl_n[9] bl[10] bl_n[10] bl[11] bl_n[11] q[3] d[3] bl[12] bl_n[12] bl[13] bl_n[13] bl[14] bl_n[14] bl[15] bl_n[15] q[4] d[4] bl[16] bl_n[16] bl[17] bl_n[17] bl[18] bl_n[18] bl[19] bl_n[19] q[5] d[5] bl[20] bl_n[20] bl[21] bl_n[21] bl[22] bl_n[22] bl[23] bl_n[23] q[6] d[6] bl[24] bl_n[24] bl[25] bl_n[25] bl[26] bl_n[26] bl[27] bl_n[27] q[7] d[7] bl[28] bl_n[28] bl[29] bl_n[29] bl[30] bl_n[30] bl[31] bl_n[31] mux[0] mux[1] mux[2] mux[3]
Xprecharge[0] vdd nwell bl[0] bl_n[0] precharge_n SP6T3Precharge_26L100W
Xprecharge[1] vdd nwell bl[1] bl_n[1] precharge_n SP6T3Precharge_26L100W
Xprecharge[2] vdd nwell bl[2] bl_n[2] precharge_n SP6T3Precharge_26L100W
Xprecharge[3] vdd nwell bl[3] bl_n[3] precharge_n SP6T3Precharge_26L100W
Xprecharge[4] vdd nwell bl[4] bl_n[4] precharge_n SP6T3Precharge_26L100W
Xprecharge[5] vdd nwell bl[5] bl_n[5] precharge_n SP6T3Precharge_26L100W
Xprecharge[6] vdd nwell bl[6] bl_n[6] precharge_n SP6T3Precharge_26L100W
Xprecharge[7] vdd nwell bl[7] bl_n[7] precharge_n SP6T3Precharge_26L100W
Xprecharge[8] vdd nwell bl[8] bl_n[8] precharge_n SP6T3Precharge_26L100W
Xprecharge[9] vdd nwell bl[9] bl_n[9] precharge_n SP6T3Precharge_26L100W
Xprecharge[10] vdd nwell bl[10] bl_n[10] precharge_n SP6T3Precharge_26L100W
Xprecharge[11] vdd nwell bl[11] bl_n[11] precharge_n SP6T3Precharge_26L100W
Xprecharge[12] vdd nwell bl[12] bl_n[12] precharge_n SP6T3Precharge_26L100W
Xprecharge[13] vdd nwell bl[13] bl_n[13] precharge_n SP6T3Precharge_26L100W
Xprecharge[14] vdd nwell bl[14] bl_n[14] precharge_n SP6T3Precharge_26L100W
Xprecharge[15] vdd nwell bl[15] bl_n[15] precharge_n SP6T3Precharge_26L100W
Xprecharge[16] vdd nwell bl[16] bl_n[16] precharge_n SP6T3Precharge_26L100W
Xprecharge[17] vdd nwell bl[17] bl_n[17] precharge_n SP6T3Precharge_26L100W
Xprecharge[18] vdd nwell bl[18] bl_n[18] precharge_n SP6T3Precharge_26L100W
Xprecharge[19] vdd nwell bl[19] bl_n[19] precharge_n SP6T3Precharge_26L100W
Xprecharge[20] vdd nwell bl[20] bl_n[20] precharge_n SP6T3Precharge_26L100W
Xprecharge[21] vdd nwell bl[21] bl_n[21] precharge_n SP6T3Precharge_26L100W
Xprecharge[22] vdd nwell bl[22] bl_n[22] precharge_n SP6T3Precharge_26L100W
Xprecharge[23] vdd nwell bl[23] bl_n[23] precharge_n SP6T3Precharge_26L100W
Xprecharge[24] vdd nwell bl[24] bl_n[24] precharge_n SP6T3Precharge_26L100W
Xprecharge[25] vdd nwell bl[25] bl_n[25] precharge_n SP6T3Precharge_26L100W
Xprecharge[26] vdd nwell bl[26] bl_n[26] precharge_n SP6T3Precharge_26L100W
Xprecharge[27] vdd nwell bl[27] bl_n[27] precharge_n SP6T3Precharge_26L100W
Xprecharge[28] vdd nwell bl[28] bl_n[28] precharge_n SP6T3Precharge_26L100W
Xprecharge[29] vdd nwell bl[29] bl_n[29] precharge_n SP6T3Precharge_26L100W
Xprecharge[30] vdd nwell bl[30] bl_n[30] precharge_n SP6T3Precharge_26L100W
Xprecharge[31] vdd nwell bl[31] bl_n[31] precharge_n SP6T3Precharge_26L100W
Xcolmux[0] bl[0] bl_n[0] mux[0] bl[1] bl_n[1] mux[1] bl[2] bl_n[2] mux[2] bl[3] bl_n[3] mux[3] vss muxbl[0] muxbl_n[0] SP6T3ColMux_4MN26L580W1R
Xcolmux[1] bl[4] bl_n[4] mux[0] bl[5] bl_n[5] mux[1] bl[6] bl_n[6] mux[2] bl[7] bl_n[7] mux[3] vss muxbl[1] muxbl_n[1] SP6T3ColMux_4MN26L580W1R
Xcolmux[2] bl[8] bl_n[8] mux[0] bl[9] bl_n[9] mux[1] bl[10] bl_n[10] mux[2] bl[11] bl_n[11] mux[3] vss muxbl[2] muxbl_n[2] SP6T3ColMux_4MN26L580W1R
Xcolmux[3] bl[12] bl_n[12] mux[0] bl[13] bl_n[13] mux[1] bl[14] bl_n[14] mux[2] bl[15] bl_n[15] mux[3] vss muxbl[3] muxbl_n[3] SP6T3ColMux_4MN26L580W1R
Xcolmux[4] bl[16] bl_n[16] mux[0] bl[17] bl_n[17] mux[1] bl[18] bl_n[18] mux[2] bl[19] bl_n[19] mux[3] vss muxbl[4] muxbl_n[4] SP6T3ColMux_4MN26L580W1R
Xcolmux[5] bl[20] bl_n[20] mux[0] bl[21] bl_n[21] mux[1] bl[22] bl_n[22] mux[2] bl[23] bl_n[23] mux[3] vss muxbl[5] muxbl_n[5] SP6T3ColMux_4MN26L580W1R
Xcolmux[6] bl[24] bl_n[24] mux[0] bl[25] bl_n[25] mux[1] bl[26] bl_n[26] mux[2] bl[27] bl_n[27] mux[3] vss muxbl[6] muxbl_n[6] SP6T3ColMux_4MN26L580W1R
Xcolmux[7] bl[28] bl_n[28] mux[0] bl[29] bl_n[29] mux[1] bl[30] bl_n[30] mux[2] bl[31] bl_n[31] mux[3] vss muxbl[7] muxbl_n[7] SP6T3ColMux_4MN26L580W1R
Xrw[0] vss vdd d[0] q[0] muxbl[0] muxbl_n[0] intclk we_n SP6T3ReadWrite_CM4MN26L580W1R_WD26L380W
Xrw[1] vss vdd d[1] q[1] muxbl[1] muxbl_n[1] intclk we_n SP6T3ReadWrite_CM4MN26L580W1R_WD26L380W
Xrw[2] vss vdd d[2] q[2] muxbl[2] muxbl_n[2] intclk we_n SP6T3ReadWrite_CM4MN26L580W1R_WD26L380W
Xrw[3] vss vdd d[3] q[3] muxbl[3] muxbl_n[3] intclk we_n SP6T3ReadWrite_CM4MN26L580W1R_WD26L380W
Xrw[4] vss vdd d[4] q[4] muxbl[4] muxbl_n[4] intclk we_n SP6T3ReadWrite_CM4MN26L580W1R_WD26L380W
Xrw[5] vss vdd d[5] q[5] muxbl[5] muxbl_n[5] intclk we_n SP6T3ReadWrite_CM4MN26L580W1R_WD26L380W
Xrw[6] vss vdd d[6] q[6] muxbl[6] muxbl_n[6] intclk we_n SP6T3ReadWrite_CM4MN26L580W1R_WD26L380W
Xrw[7] vss vdd d[7] q[7] muxbl[7] muxbl_n[7] intclk we_n SP6T3ReadWrite_CM4MN26L580W1R_WD26L380W
Xclkwe vss vdd clk intclk we we_en we_n SP6T3ClockWE
.ends SP6T3ColPeriph8B_PC26L100W_CM4MN26L580W1R

.subckt SP6T3Column_128R_CP8B_CM4MN26L580W1R_PC26L100W vss vdd wl[0] wl[1] wl[2] wl[3] wl[4] wl[5] wl[6] wl[7] wl[8] wl[9] wl[10] wl[11] wl[12] wl[13] wl[14] wl[15] wl[16] wl[17] wl[18] wl[19] wl[20] wl[21] wl[22] wl[23] wl[24] wl[25] wl[26] wl[27] wl[28] wl[29] wl[30] wl[31] wl[32] wl[33] wl[34] wl[35] wl[36] wl[37] wl[38] wl[39] wl[40] wl[41] wl[42] wl[43] wl[44] wl[45] wl[46] wl[47] wl[48] wl[49] wl[50] wl[51] wl[52] wl[53] wl[54] wl[55] wl[56] wl[57] wl[58] wl[59] wl[60] wl[61] wl[62] wl[63] wl[64] wl[65] wl[66] wl[67] wl[68] wl[69] wl[70] wl[71] wl[72] wl[73] wl[74] wl[75] wl[76] wl[77] wl[78] wl[79] wl[80] wl[81] wl[82] wl[83] wl[84] wl[85] wl[86] wl[87] wl[88] wl[89] wl[90] wl[91] wl[92] wl[93] wl[94] wl[95] wl[96] wl[97] wl[98] wl[99] wl[100] wl[101] wl[102] wl[103] wl[104] wl[105] wl[106] wl[107] wl[108] wl[109] wl[110] wl[111] wl[112] wl[113] wl[114] wl[115] wl[116] wl[117] wl[118] wl[119] wl[120] wl[121] wl[122] wl[123] wl[124] wl[125] wl[126] wl[127] q[0] d[0] q[1] d[1] q[2] d[2] q[3] d[3] q[4] d[4] q[5] d[5] q[6] d[6] q[7] d[7] we clk we_en precharge_n mux[0] mux[1] mux[2] mux[3]
Xarray vss vdd wl[0] wl[1] wl[2] wl[3] wl[4] wl[5] wl[6] wl[7] wl[8] wl[9] wl[10] wl[11] wl[12] wl[13] wl[14] wl[15] wl[16] wl[17] wl[18] wl[19] wl[20] wl[21] wl[22] wl[23] wl[24] wl[25] wl[26] wl[27] wl[28] wl[29] wl[30] wl[31] wl[32] wl[33] wl[34] wl[35] wl[36] wl[37] wl[38] wl[39] wl[40] wl[41] wl[42] wl[43] wl[44] wl[45] wl[46] wl[47] wl[48] wl[49] wl[50] wl[51] wl[52] wl[53] wl[54] wl[55] wl[56] wl[57] wl[58] wl[59] wl[60] wl[61] wl[62] wl[63] wl[64] wl[65] wl[66] wl[67] wl[68] wl[69] wl[70] wl[71] wl[72] wl[73] wl[74] wl[75] wl[76] wl[77] wl[78] wl[79] wl[80] wl[81] wl[82] wl[83] wl[84] wl[85] wl[86] wl[87] wl[88] wl[89] wl[90] wl[91] wl[92] wl[93] wl[94] wl[95] wl[96] wl[97] wl[98] wl[99] wl[100] wl[101] wl[102] wl[103] wl[104] wl[105] wl[106] wl[107] wl[108] wl[109] wl[110] wl[111] wl[112] wl[113] wl[114] wl[115] wl[116] wl[117] wl[118] wl[119] wl[120] wl[121] wl[122] wl[123] wl[124] wl[125] wl[126] wl[127] bl[0] bl_n[0] bl[1] bl_n[1] bl[2] bl_n[2] bl[3] bl_n[3] bl[4] bl_n[4] bl[5] bl_n[5] bl[6] bl_n[6] bl[7] bl_n[7] bl[8] bl_n[8] bl[9] bl_n[9] bl[10] bl_n[10] bl[11] bl_n[11] bl[12] bl_n[12] bl[13] bl_n[13] bl[14] bl_n[14] bl[15] bl_n[15] bl[16] bl_n[16] bl[17] bl_n[17] bl[18] bl_n[18] bl[19] bl_n[19] bl[20] bl_n[20] bl[21] bl_n[21] bl[22] bl_n[22] bl[23] bl_n[23] bl[24] bl_n[24] bl[25] bl_n[25] bl[26] bl_n[26] bl[27] bl_n[27] bl[28] bl_n[28] bl[29] bl_n[29] bl[30] bl_n[30] bl[31] bl_n[31] SP6T3Array_128X32BC
Xperiph vss vdd vdd clk precharge_n we we_en q[0] d[0] bl[0] bl_n[0] bl[1] bl_n[1] bl[2] bl_n[2] bl[3] bl_n[3] q[1] d[1] bl[4] bl_n[4] bl[5] bl_n[5] bl[6] bl_n[6] bl[7] bl_n[7] q[2] d[2] bl[8] bl_n[8] bl[9] bl_n[9] bl[10] bl_n[10] bl[11] bl_n[11] q[3] d[3] bl[12] bl_n[12] bl[13] bl_n[13] bl[14] bl_n[14] bl[15] bl_n[15] q[4] d[4] bl[16] bl_n[16] bl[17] bl_n[17] bl[18] bl_n[18] bl[19] bl_n[19] q[5] d[5] bl[20] bl_n[20] bl[21] bl_n[21] bl[22] bl_n[22] bl[23] bl_n[23] q[6] d[6] bl[24] bl_n[24] bl[25] bl_n[25] bl[26] bl_n[26] bl[27] bl_n[27] q[7] d[7] bl[28] bl_n[28] bl[29] bl_n[29] bl[30] bl_n[30] bl[31] bl_n[31] mux[0] mux[1] mux[2] mux[3] SP6T3ColPeriph8B_PC26L100W_CM4MN26L580W1R
.ends SP6T3Column_128R_CP8B_CM4MN26L580W1R_PC26L100W

.subckt SP6T3ColumnBlock_COL128R_CP8B_CM4MN26L580W1R_PC26L100W_4WE vss vdd clk precharge_n we_en wl[0] wl[1] wl[2] wl[3] wl[4] wl[5] wl[6] wl[7] wl[8] wl[9] wl[10] wl[11] wl[12] wl[13] wl[14] wl[15] wl[16] wl[17] wl[18] wl[19] wl[20] wl[21] wl[22] wl[23] wl[24] wl[25] wl[26] wl[27] wl[28] wl[29] wl[30] wl[31] wl[32] wl[33] wl[34] wl[35] wl[36] wl[37] wl[38] wl[39] wl[40] wl[41] wl[42] wl[43] wl[44] wl[45] wl[46] wl[47] wl[48] wl[49] wl[50] wl[51] wl[52] wl[53] wl[54] wl[55] wl[56] wl[57] wl[58] wl[59] wl[60] wl[61] wl[62] wl[63] wl[64] wl[65] wl[66] wl[67] wl[68] wl[69] wl[70] wl[71] wl[72] wl[73] wl[74] wl[75] wl[76] wl[77] wl[78] wl[79] wl[80] wl[81] wl[82] wl[83] wl[84] wl[85] wl[86] wl[87] wl[88] wl[89] wl[90] wl[91] wl[92] wl[93] wl[94] wl[95] wl[96] wl[97] wl[98] wl[99] wl[100] wl[101] wl[102] wl[103] wl[104] wl[105] wl[106] wl[107] wl[108] wl[109] wl[110] wl[111] wl[112] wl[113] wl[114] wl[115] wl[116] wl[117] wl[118] wl[119] wl[120] wl[121] wl[122] wl[123] wl[124] wl[125] wl[126] wl[127] mux[0] mux[1] mux[2] mux[3] we[0] q[0] d[0] q[1] d[1] q[2] d[2] q[3] d[3] q[4] d[4] q[5] d[5] q[6] d[6] q[7] d[7] we[1] q[8] d[8] q[9] d[9] q[10] d[10] q[11] d[11] q[12] d[12] q[13] d[13] q[14] d[14] q[15] d[15] we[2] q[16] d[16] q[17] d[17] q[18] d[18] q[19] d[19] q[20] d[20] q[21] d[21] q[22] d[22] q[23] d[23] we[3] q[24] d[24] q[25] d[25] q[26] d[26] q[27] d[27] q[28] d[28] q[29] d[29] q[30] d[30] q[31] d[31]
Xcolumn[0] vss vdd wl[0] wl[1] wl[2] wl[3] wl[4] wl[5] wl[6] wl[7] wl[8] wl[9] wl[10] wl[11] wl[12] wl[13] wl[14] wl[15] wl[16] wl[17] wl[18] wl[19] wl[20] wl[21] wl[22] wl[23] wl[24] wl[25] wl[26] wl[27] wl[28] wl[29] wl[30] wl[31] wl[32] wl[33] wl[34] wl[35] wl[36] wl[37] wl[38] wl[39] wl[40] wl[41] wl[42] wl[43] wl[44] wl[45] wl[46] wl[47] wl[48] wl[49] wl[50] wl[51] wl[52] wl[53] wl[54] wl[55] wl[56] wl[57] wl[58] wl[59] wl[60] wl[61] wl[62] wl[63] wl[64] wl[65] wl[66] wl[67] wl[68] wl[69] wl[70] wl[71] wl[72] wl[73] wl[74] wl[75] wl[76] wl[77] wl[78] wl[79] wl[80] wl[81] wl[82] wl[83] wl[84] wl[85] wl[86] wl[87] wl[88] wl[89] wl[90] wl[91] wl[92] wl[93] wl[94] wl[95] wl[96] wl[97] wl[98] wl[99] wl[100] wl[101] wl[102] wl[103] wl[104] wl[105] wl[106] wl[107] wl[108] wl[109] wl[110] wl[111] wl[112] wl[113] wl[114] wl[115] wl[116] wl[117] wl[118] wl[119] wl[120] wl[121] wl[122] wl[123] wl[124] wl[125] wl[126] wl[127] q[0] d[0] q[1] d[1] q[2] d[2] q[3] d[3] q[4] d[4] q[5] d[5] q[6] d[6] q[7] d[7] we[0] clk we_en precharge_n mux[0] mux[1] mux[2] mux[3] SP6T3Column_128R_CP8B_CM4MN26L580W1R_PC26L100W
Xcolumn[1] vss vdd wl[0] wl[1] wl[2] wl[3] wl[4] wl[5] wl[6] wl[7] wl[8] wl[9] wl[10] wl[11] wl[12] wl[13] wl[14] wl[15] wl[16] wl[17] wl[18] wl[19] wl[20] wl[21] wl[22] wl[23] wl[24] wl[25] wl[26] wl[27] wl[28] wl[29] wl[30] wl[31] wl[32] wl[33] wl[34] wl[35] wl[36] wl[37] wl[38] wl[39] wl[40] wl[41] wl[42] wl[43] wl[44] wl[45] wl[46] wl[47] wl[48] wl[49] wl[50] wl[51] wl[52] wl[53] wl[54] wl[55] wl[56] wl[57] wl[58] wl[59] wl[60] wl[61] wl[62] wl[63] wl[64] wl[65] wl[66] wl[67] wl[68] wl[69] wl[70] wl[71] wl[72] wl[73] wl[74] wl[75] wl[76] wl[77] wl[78] wl[79] wl[80] wl[81] wl[82] wl[83] wl[84] wl[85] wl[86] wl[87] wl[88] wl[89] wl[90] wl[91] wl[92] wl[93] wl[94] wl[95] wl[96] wl[97] wl[98] wl[99] wl[100] wl[101] wl[102] wl[103] wl[104] wl[105] wl[106] wl[107] wl[108] wl[109] wl[110] wl[111] wl[112] wl[113] wl[114] wl[115] wl[116] wl[117] wl[118] wl[119] wl[120] wl[121] wl[122] wl[123] wl[124] wl[125] wl[126] wl[127] q[8] d[8] q[9] d[9] q[10] d[10] q[11] d[11] q[12] d[12] q[13] d[13] q[14] d[14] q[15] d[15] we[1] clk we_en precharge_n mux[0] mux[1] mux[2] mux[3] SP6T3Column_128R_CP8B_CM4MN26L580W1R_PC26L100W
Xcolumn[2] vss vdd wl[0] wl[1] wl[2] wl[3] wl[4] wl[5] wl[6] wl[7] wl[8] wl[9] wl[10] wl[11] wl[12] wl[13] wl[14] wl[15] wl[16] wl[17] wl[18] wl[19] wl[20] wl[21] wl[22] wl[23] wl[24] wl[25] wl[26] wl[27] wl[28] wl[29] wl[30] wl[31] wl[32] wl[33] wl[34] wl[35] wl[36] wl[37] wl[38] wl[39] wl[40] wl[41] wl[42] wl[43] wl[44] wl[45] wl[46] wl[47] wl[48] wl[49] wl[50] wl[51] wl[52] wl[53] wl[54] wl[55] wl[56] wl[57] wl[58] wl[59] wl[60] wl[61] wl[62] wl[63] wl[64] wl[65] wl[66] wl[67] wl[68] wl[69] wl[70] wl[71] wl[72] wl[73] wl[74] wl[75] wl[76] wl[77] wl[78] wl[79] wl[80] wl[81] wl[82] wl[83] wl[84] wl[85] wl[86] wl[87] wl[88] wl[89] wl[90] wl[91] wl[92] wl[93] wl[94] wl[95] wl[96] wl[97] wl[98] wl[99] wl[100] wl[101] wl[102] wl[103] wl[104] wl[105] wl[106] wl[107] wl[108] wl[109] wl[110] wl[111] wl[112] wl[113] wl[114] wl[115] wl[116] wl[117] wl[118] wl[119] wl[120] wl[121] wl[122] wl[123] wl[124] wl[125] wl[126] wl[127] q[16] d[16] q[17] d[17] q[18] d[18] q[19] d[19] q[20] d[20] q[21] d[21] q[22] d[22] q[23] d[23] we[2] clk we_en precharge_n mux[0] mux[1] mux[2] mux[3] SP6T3Column_128R_CP8B_CM4MN26L580W1R_PC26L100W
Xcolumn[3] vss vdd wl[0] wl[1] wl[2] wl[3] wl[4] wl[5] wl[6] wl[7] wl[8] wl[9] wl[10] wl[11] wl[12] wl[13] wl[14] wl[15] wl[16] wl[17] wl[18] wl[19] wl[20] wl[21] wl[22] wl[23] wl[24] wl[25] wl[26] wl[27] wl[28] wl[29] wl[30] wl[31] wl[32] wl[33] wl[34] wl[35] wl[36] wl[37] wl[38] wl[39] wl[40] wl[41] wl[42] wl[43] wl[44] wl[45] wl[46] wl[47] wl[48] wl[49] wl[50] wl[51] wl[52] wl[53] wl[54] wl[55] wl[56] wl[57] wl[58] wl[59] wl[60] wl[61] wl[62] wl[63] wl[64] wl[65] wl[66] wl[67] wl[68] wl[69] wl[70] wl[71] wl[72] wl[73] wl[74] wl[75] wl[76] wl[77] wl[78] wl[79] wl[80] wl[81] wl[82] wl[83] wl[84] wl[85] wl[86] wl[87] wl[88] wl[89] wl[90] wl[91] wl[92] wl[93] wl[94] wl[95] wl[96] wl[97] wl[98] wl[99] wl[100] wl[101] wl[102] wl[103] wl[104] wl[105] wl[106] wl[107] wl[108] wl[109] wl[110] wl[111] wl[112] wl[113] wl[114] wl[115] wl[116] wl[117] wl[118] wl[119] wl[120] wl[121] wl[122] wl[123] wl[124] wl[125] wl[126] wl[127] q[24] d[24] q[25] d[25] q[26] d[26] q[27] d[27] q[28] d[28] q[29] d[29] q[30] d[30] q[31] d[31] we[3] clk we_en precharge_n mux[0] mux[1] mux[2] mux[3] SP6T3Column_128R_CP8B_CM4MN26L580W1R_PC26L100W
.ends SP6T3ColumnBlock_COL128R_CP8B_CM4MN26L580W1R_PC26L100W_4WE

.subckt SP6T3WLDriver_N26L400WP26L800W vss substrate vdd nwell wl_n wl_drive
Xnmos1 vss wl_n wl_drive substrate sg13_lv_nmos l=1.3e-07 w=2e-06
Xnmos2 wl_drive wl_n vss substrate sg13_lv_nmos l=1.3e-07 w=2e-06
Xpmos1 vdd wl_n wl_drive nwell sg13_lv_pmos l=1.3e-07 w=4e-06
Xpmos2 wl_drive wl_n vdd nwell sg13_lv_pmos l=1.3e-07 w=4e-06
.ends SP6T3WLDriver_N26L400WP26L800W

.subckt SP6T3WLDriverBC_N26L400WP26L800W vss vdd
.ends SP6T3WLDriverBC_N26L400WP26L800W

.subckt SP6T3WLDriverCol_128RN26L400WP26L800W vss vdd wl[0] wl_n[0] wl[1] wl_n[1] wl[2] wl_n[2] wl[3] wl_n[3] wl[4] wl_n[4] wl[5] wl_n[5] wl[6] wl_n[6] wl[7] wl_n[7] wl[8] wl_n[8] wl[9] wl_n[9] wl[10] wl_n[10] wl[11] wl_n[11] wl[12] wl_n[12] wl[13] wl_n[13] wl[14] wl_n[14] wl[15] wl_n[15] wl[16] wl_n[16] wl[17] wl_n[17] wl[18] wl_n[18] wl[19] wl_n[19] wl[20] wl_n[20] wl[21] wl_n[21] wl[22] wl_n[22] wl[23] wl_n[23] wl[24] wl_n[24] wl[25] wl_n[25] wl[26] wl_n[26] wl[27] wl_n[27] wl[28] wl_n[28] wl[29] wl_n[29] wl[30] wl_n[30] wl[31] wl_n[31] wl[32] wl_n[32] wl[33] wl_n[33] wl[34] wl_n[34] wl[35] wl_n[35] wl[36] wl_n[36] wl[37] wl_n[37] wl[38] wl_n[38] wl[39] wl_n[39] wl[40] wl_n[40] wl[41] wl_n[41] wl[42] wl_n[42] wl[43] wl_n[43] wl[44] wl_n[44] wl[45] wl_n[45] wl[46] wl_n[46] wl[47] wl_n[47] wl[48] wl_n[48] wl[49] wl_n[49] wl[50] wl_n[50] wl[51] wl_n[51] wl[52] wl_n[52] wl[53] wl_n[53] wl[54] wl_n[54] wl[55] wl_n[55] wl[56] wl_n[56] wl[57] wl_n[57] wl[58] wl_n[58] wl[59] wl_n[59] wl[60] wl_n[60] wl[61] wl_n[61] wl[62] wl_n[62] wl[63] wl_n[63] wl[64] wl_n[64] wl[65] wl_n[65] wl[66] wl_n[66] wl[67] wl_n[67] wl[68] wl_n[68] wl[69] wl_n[69] wl[70] wl_n[70] wl[71] wl_n[71] wl[72] wl_n[72] wl[73] wl_n[73] wl[74] wl_n[74] wl[75] wl_n[75] wl[76] wl_n[76] wl[77] wl_n[77] wl[78] wl_n[78] wl[79] wl_n[79] wl[80] wl_n[80] wl[81] wl_n[81] wl[82] wl_n[82] wl[83] wl_n[83] wl[84] wl_n[84] wl[85] wl_n[85] wl[86] wl_n[86] wl[87] wl_n[87] wl[88] wl_n[88] wl[89] wl_n[89] wl[90] wl_n[90] wl[91] wl_n[91] wl[92] wl_n[92] wl[93] wl_n[93] wl[94] wl_n[94] wl[95] wl_n[95] wl[96] wl_n[96] wl[97] wl_n[97] wl[98] wl_n[98] wl[99] wl_n[99] wl[100] wl_n[100] wl[101] wl_n[101] wl[102] wl_n[102] wl[103] wl_n[103] wl[104] wl_n[104] wl[105] wl_n[105] wl[106] wl_n[106] wl[107] wl_n[107] wl[108] wl_n[108] wl[109] wl_n[109] wl[110] wl_n[110] wl[111] wl_n[111] wl[112] wl_n[112] wl[113] wl_n[113] wl[114] wl_n[114] wl[115] wl_n[115] wl[116] wl_n[116] wl[117] wl_n[117] wl[118] wl_n[118] wl[119] wl_n[119] wl[120] wl_n[120] wl[121] wl_n[121] wl[122] wl_n[122] wl[123] wl_n[123] wl[124] wl_n[124] wl[125] wl_n[125] wl[126] wl_n[126] wl[127] wl_n[127]
Xdriver[0] vss vss vdd vdd wl_n[0] wl[0] SP6T3WLDriver_N26L400WP26L800W
Xdriver[1] vss vss vdd vdd wl_n[1] wl[1] SP6T3WLDriver_N26L400WP26L800W
Xdriver[2] vss vss vdd vdd wl_n[2] wl[2] SP6T3WLDriver_N26L400WP26L800W
Xdriver[3] vss vss vdd vdd wl_n[3] wl[3] SP6T3WLDriver_N26L400WP26L800W
Xdriver[4] vss vss vdd vdd wl_n[4] wl[4] SP6T3WLDriver_N26L400WP26L800W
Xdriver[5] vss vss vdd vdd wl_n[5] wl[5] SP6T3WLDriver_N26L400WP26L800W
Xdriver[6] vss vss vdd vdd wl_n[6] wl[6] SP6T3WLDriver_N26L400WP26L800W
Xdriver[7] vss vss vdd vdd wl_n[7] wl[7] SP6T3WLDriver_N26L400WP26L800W
Xdriver[8] vss vss vdd vdd wl_n[8] wl[8] SP6T3WLDriver_N26L400WP26L800W
Xdriver[9] vss vss vdd vdd wl_n[9] wl[9] SP6T3WLDriver_N26L400WP26L800W
Xdriver[10] vss vss vdd vdd wl_n[10] wl[10] SP6T3WLDriver_N26L400WP26L800W
Xdriver[11] vss vss vdd vdd wl_n[11] wl[11] SP6T3WLDriver_N26L400WP26L800W
Xdriver[12] vss vss vdd vdd wl_n[12] wl[12] SP6T3WLDriver_N26L400WP26L800W
Xdriver[13] vss vss vdd vdd wl_n[13] wl[13] SP6T3WLDriver_N26L400WP26L800W
Xdriver[14] vss vss vdd vdd wl_n[14] wl[14] SP6T3WLDriver_N26L400WP26L800W
Xdriver[15] vss vss vdd vdd wl_n[15] wl[15] SP6T3WLDriver_N26L400WP26L800W
Xdriver[16] vss vss vdd vdd wl_n[16] wl[16] SP6T3WLDriver_N26L400WP26L800W
Xdriver[17] vss vss vdd vdd wl_n[17] wl[17] SP6T3WLDriver_N26L400WP26L800W
Xdriver[18] vss vss vdd vdd wl_n[18] wl[18] SP6T3WLDriver_N26L400WP26L800W
Xdriver[19] vss vss vdd vdd wl_n[19] wl[19] SP6T3WLDriver_N26L400WP26L800W
Xdriver[20] vss vss vdd vdd wl_n[20] wl[20] SP6T3WLDriver_N26L400WP26L800W
Xdriver[21] vss vss vdd vdd wl_n[21] wl[21] SP6T3WLDriver_N26L400WP26L800W
Xdriver[22] vss vss vdd vdd wl_n[22] wl[22] SP6T3WLDriver_N26L400WP26L800W
Xdriver[23] vss vss vdd vdd wl_n[23] wl[23] SP6T3WLDriver_N26L400WP26L800W
Xdriver[24] vss vss vdd vdd wl_n[24] wl[24] SP6T3WLDriver_N26L400WP26L800W
Xdriver[25] vss vss vdd vdd wl_n[25] wl[25] SP6T3WLDriver_N26L400WP26L800W
Xdriver[26] vss vss vdd vdd wl_n[26] wl[26] SP6T3WLDriver_N26L400WP26L800W
Xdriver[27] vss vss vdd vdd wl_n[27] wl[27] SP6T3WLDriver_N26L400WP26L800W
Xdriver[28] vss vss vdd vdd wl_n[28] wl[28] SP6T3WLDriver_N26L400WP26L800W
Xdriver[29] vss vss vdd vdd wl_n[29] wl[29] SP6T3WLDriver_N26L400WP26L800W
Xdriver[30] vss vss vdd vdd wl_n[30] wl[30] SP6T3WLDriver_N26L400WP26L800W
Xdriver[31] vss vss vdd vdd wl_n[31] wl[31] SP6T3WLDriver_N26L400WP26L800W
Xdriver[32] vss vss vdd vdd wl_n[32] wl[32] SP6T3WLDriver_N26L400WP26L800W
Xdriver[33] vss vss vdd vdd wl_n[33] wl[33] SP6T3WLDriver_N26L400WP26L800W
Xdriver[34] vss vss vdd vdd wl_n[34] wl[34] SP6T3WLDriver_N26L400WP26L800W
Xdriver[35] vss vss vdd vdd wl_n[35] wl[35] SP6T3WLDriver_N26L400WP26L800W
Xdriver[36] vss vss vdd vdd wl_n[36] wl[36] SP6T3WLDriver_N26L400WP26L800W
Xdriver[37] vss vss vdd vdd wl_n[37] wl[37] SP6T3WLDriver_N26L400WP26L800W
Xdriver[38] vss vss vdd vdd wl_n[38] wl[38] SP6T3WLDriver_N26L400WP26L800W
Xdriver[39] vss vss vdd vdd wl_n[39] wl[39] SP6T3WLDriver_N26L400WP26L800W
Xdriver[40] vss vss vdd vdd wl_n[40] wl[40] SP6T3WLDriver_N26L400WP26L800W
Xdriver[41] vss vss vdd vdd wl_n[41] wl[41] SP6T3WLDriver_N26L400WP26L800W
Xdriver[42] vss vss vdd vdd wl_n[42] wl[42] SP6T3WLDriver_N26L400WP26L800W
Xdriver[43] vss vss vdd vdd wl_n[43] wl[43] SP6T3WLDriver_N26L400WP26L800W
Xdriver[44] vss vss vdd vdd wl_n[44] wl[44] SP6T3WLDriver_N26L400WP26L800W
Xdriver[45] vss vss vdd vdd wl_n[45] wl[45] SP6T3WLDriver_N26L400WP26L800W
Xdriver[46] vss vss vdd vdd wl_n[46] wl[46] SP6T3WLDriver_N26L400WP26L800W
Xdriver[47] vss vss vdd vdd wl_n[47] wl[47] SP6T3WLDriver_N26L400WP26L800W
Xdriver[48] vss vss vdd vdd wl_n[48] wl[48] SP6T3WLDriver_N26L400WP26L800W
Xdriver[49] vss vss vdd vdd wl_n[49] wl[49] SP6T3WLDriver_N26L400WP26L800W
Xdriver[50] vss vss vdd vdd wl_n[50] wl[50] SP6T3WLDriver_N26L400WP26L800W
Xdriver[51] vss vss vdd vdd wl_n[51] wl[51] SP6T3WLDriver_N26L400WP26L800W
Xdriver[52] vss vss vdd vdd wl_n[52] wl[52] SP6T3WLDriver_N26L400WP26L800W
Xdriver[53] vss vss vdd vdd wl_n[53] wl[53] SP6T3WLDriver_N26L400WP26L800W
Xdriver[54] vss vss vdd vdd wl_n[54] wl[54] SP6T3WLDriver_N26L400WP26L800W
Xdriver[55] vss vss vdd vdd wl_n[55] wl[55] SP6T3WLDriver_N26L400WP26L800W
Xdriver[56] vss vss vdd vdd wl_n[56] wl[56] SP6T3WLDriver_N26L400WP26L800W
Xdriver[57] vss vss vdd vdd wl_n[57] wl[57] SP6T3WLDriver_N26L400WP26L800W
Xdriver[58] vss vss vdd vdd wl_n[58] wl[58] SP6T3WLDriver_N26L400WP26L800W
Xdriver[59] vss vss vdd vdd wl_n[59] wl[59] SP6T3WLDriver_N26L400WP26L800W
Xdriver[60] vss vss vdd vdd wl_n[60] wl[60] SP6T3WLDriver_N26L400WP26L800W
Xdriver[61] vss vss vdd vdd wl_n[61] wl[61] SP6T3WLDriver_N26L400WP26L800W
Xdriver[62] vss vss vdd vdd wl_n[62] wl[62] SP6T3WLDriver_N26L400WP26L800W
Xdriver[63] vss vss vdd vdd wl_n[63] wl[63] SP6T3WLDriver_N26L400WP26L800W
Xdriver[64] vss vss vdd vdd wl_n[64] wl[64] SP6T3WLDriver_N26L400WP26L800W
Xdriver[65] vss vss vdd vdd wl_n[65] wl[65] SP6T3WLDriver_N26L400WP26L800W
Xdriver[66] vss vss vdd vdd wl_n[66] wl[66] SP6T3WLDriver_N26L400WP26L800W
Xdriver[67] vss vss vdd vdd wl_n[67] wl[67] SP6T3WLDriver_N26L400WP26L800W
Xdriver[68] vss vss vdd vdd wl_n[68] wl[68] SP6T3WLDriver_N26L400WP26L800W
Xdriver[69] vss vss vdd vdd wl_n[69] wl[69] SP6T3WLDriver_N26L400WP26L800W
Xdriver[70] vss vss vdd vdd wl_n[70] wl[70] SP6T3WLDriver_N26L400WP26L800W
Xdriver[71] vss vss vdd vdd wl_n[71] wl[71] SP6T3WLDriver_N26L400WP26L800W
Xdriver[72] vss vss vdd vdd wl_n[72] wl[72] SP6T3WLDriver_N26L400WP26L800W
Xdriver[73] vss vss vdd vdd wl_n[73] wl[73] SP6T3WLDriver_N26L400WP26L800W
Xdriver[74] vss vss vdd vdd wl_n[74] wl[74] SP6T3WLDriver_N26L400WP26L800W
Xdriver[75] vss vss vdd vdd wl_n[75] wl[75] SP6T3WLDriver_N26L400WP26L800W
Xdriver[76] vss vss vdd vdd wl_n[76] wl[76] SP6T3WLDriver_N26L400WP26L800W
Xdriver[77] vss vss vdd vdd wl_n[77] wl[77] SP6T3WLDriver_N26L400WP26L800W
Xdriver[78] vss vss vdd vdd wl_n[78] wl[78] SP6T3WLDriver_N26L400WP26L800W
Xdriver[79] vss vss vdd vdd wl_n[79] wl[79] SP6T3WLDriver_N26L400WP26L800W
Xdriver[80] vss vss vdd vdd wl_n[80] wl[80] SP6T3WLDriver_N26L400WP26L800W
Xdriver[81] vss vss vdd vdd wl_n[81] wl[81] SP6T3WLDriver_N26L400WP26L800W
Xdriver[82] vss vss vdd vdd wl_n[82] wl[82] SP6T3WLDriver_N26L400WP26L800W
Xdriver[83] vss vss vdd vdd wl_n[83] wl[83] SP6T3WLDriver_N26L400WP26L800W
Xdriver[84] vss vss vdd vdd wl_n[84] wl[84] SP6T3WLDriver_N26L400WP26L800W
Xdriver[85] vss vss vdd vdd wl_n[85] wl[85] SP6T3WLDriver_N26L400WP26L800W
Xdriver[86] vss vss vdd vdd wl_n[86] wl[86] SP6T3WLDriver_N26L400WP26L800W
Xdriver[87] vss vss vdd vdd wl_n[87] wl[87] SP6T3WLDriver_N26L400WP26L800W
Xdriver[88] vss vss vdd vdd wl_n[88] wl[88] SP6T3WLDriver_N26L400WP26L800W
Xdriver[89] vss vss vdd vdd wl_n[89] wl[89] SP6T3WLDriver_N26L400WP26L800W
Xdriver[90] vss vss vdd vdd wl_n[90] wl[90] SP6T3WLDriver_N26L400WP26L800W
Xdriver[91] vss vss vdd vdd wl_n[91] wl[91] SP6T3WLDriver_N26L400WP26L800W
Xdriver[92] vss vss vdd vdd wl_n[92] wl[92] SP6T3WLDriver_N26L400WP26L800W
Xdriver[93] vss vss vdd vdd wl_n[93] wl[93] SP6T3WLDriver_N26L400WP26L800W
Xdriver[94] vss vss vdd vdd wl_n[94] wl[94] SP6T3WLDriver_N26L400WP26L800W
Xdriver[95] vss vss vdd vdd wl_n[95] wl[95] SP6T3WLDriver_N26L400WP26L800W
Xdriver[96] vss vss vdd vdd wl_n[96] wl[96] SP6T3WLDriver_N26L400WP26L800W
Xdriver[97] vss vss vdd vdd wl_n[97] wl[97] SP6T3WLDriver_N26L400WP26L800W
Xdriver[98] vss vss vdd vdd wl_n[98] wl[98] SP6T3WLDriver_N26L400WP26L800W
Xdriver[99] vss vss vdd vdd wl_n[99] wl[99] SP6T3WLDriver_N26L400WP26L800W
Xdriver[100] vss vss vdd vdd wl_n[100] wl[100] SP6T3WLDriver_N26L400WP26L800W
Xdriver[101] vss vss vdd vdd wl_n[101] wl[101] SP6T3WLDriver_N26L400WP26L800W
Xdriver[102] vss vss vdd vdd wl_n[102] wl[102] SP6T3WLDriver_N26L400WP26L800W
Xdriver[103] vss vss vdd vdd wl_n[103] wl[103] SP6T3WLDriver_N26L400WP26L800W
Xdriver[104] vss vss vdd vdd wl_n[104] wl[104] SP6T3WLDriver_N26L400WP26L800W
Xdriver[105] vss vss vdd vdd wl_n[105] wl[105] SP6T3WLDriver_N26L400WP26L800W
Xdriver[106] vss vss vdd vdd wl_n[106] wl[106] SP6T3WLDriver_N26L400WP26L800W
Xdriver[107] vss vss vdd vdd wl_n[107] wl[107] SP6T3WLDriver_N26L400WP26L800W
Xdriver[108] vss vss vdd vdd wl_n[108] wl[108] SP6T3WLDriver_N26L400WP26L800W
Xdriver[109] vss vss vdd vdd wl_n[109] wl[109] SP6T3WLDriver_N26L400WP26L800W
Xdriver[110] vss vss vdd vdd wl_n[110] wl[110] SP6T3WLDriver_N26L400WP26L800W
Xdriver[111] vss vss vdd vdd wl_n[111] wl[111] SP6T3WLDriver_N26L400WP26L800W
Xdriver[112] vss vss vdd vdd wl_n[112] wl[112] SP6T3WLDriver_N26L400WP26L800W
Xdriver[113] vss vss vdd vdd wl_n[113] wl[113] SP6T3WLDriver_N26L400WP26L800W
Xdriver[114] vss vss vdd vdd wl_n[114] wl[114] SP6T3WLDriver_N26L400WP26L800W
Xdriver[115] vss vss vdd vdd wl_n[115] wl[115] SP6T3WLDriver_N26L400WP26L800W
Xdriver[116] vss vss vdd vdd wl_n[116] wl[116] SP6T3WLDriver_N26L400WP26L800W
Xdriver[117] vss vss vdd vdd wl_n[117] wl[117] SP6T3WLDriver_N26L400WP26L800W
Xdriver[118] vss vss vdd vdd wl_n[118] wl[118] SP6T3WLDriver_N26L400WP26L800W
Xdriver[119] vss vss vdd vdd wl_n[119] wl[119] SP6T3WLDriver_N26L400WP26L800W
Xdriver[120] vss vss vdd vdd wl_n[120] wl[120] SP6T3WLDriver_N26L400WP26L800W
Xdriver[121] vss vss vdd vdd wl_n[121] wl[121] SP6T3WLDriver_N26L400WP26L800W
Xdriver[122] vss vss vdd vdd wl_n[122] wl[122] SP6T3WLDriver_N26L400WP26L800W
Xdriver[123] vss vss vdd vdd wl_n[123] wl[123] SP6T3WLDriver_N26L400WP26L800W
Xdriver[124] vss vss vdd vdd wl_n[124] wl[124] SP6T3WLDriver_N26L400WP26L800W
Xdriver[125] vss vss vdd vdd wl_n[125] wl[125] SP6T3WLDriver_N26L400WP26L800W
Xdriver[126] vss vss vdd vdd wl_n[126] wl[126] SP6T3WLDriver_N26L400WP26L800W
Xdriver[127] vss vss vdd vdd wl_n[127] wl[127] SP6T3WLDriver_N26L400WP26L800W
Xbc[0] vss vdd SP6T3WLDriverBC_N26L400WP26L800W
Xbc[1] vss vdd SP6T3WLDriverBC_N26L400WP26L800W
Xbc[2] vss vdd SP6T3WLDriverBC_N26L400WP26L800W
Xbc[3] vss vdd SP6T3WLDriverBC_N26L400WP26L800W
Xbc[4] vss vdd SP6T3WLDriverBC_N26L400WP26L800W
Xbc[5] vss vdd SP6T3WLDriverBC_N26L400WP26L800W
Xbc[6] vss vdd SP6T3WLDriverBC_N26L400WP26L800W
Xbc[7] vss vdd SP6T3WLDriverBC_N26L400WP26L800W
Xbc[8] vss vdd SP6T3WLDriverBC_N26L400WP26L800W
.ends SP6T3WLDriverCol_128RN26L400WP26L800W

.subckt SP6T3NonOvlClock_4S11341D1R vss vdd clk firststage[0] firststage[1] firststage[2] firststage[3] firststage[4] secondstage[0] secondstage[1] secondstage[2] secondstage[3] secondstage[4]
Xclkinv vdd vss clk clk_n inv_x0
Xfirstnand2 vdd vss firststage[0] clk secondstage[4] nand2_x0
Xfirststage[0] vdd vss firststage[0] firststage[1] inv_x0
Xfirststage[1] vdd vss firststage[1] firststage[2] inv_x0
Xfirststage[2] vdd vss firststage[2] firststage[3] inv_x0
Xfirststage[3] vdd vss firststage[3] firststage[4] inv_x0
Xsecondnand2 vdd vss secondstage[0] clk_n firststage[4] nand2_x0
Xsecondstage[0] vdd vss secondstage[0] secondstage[1] inv_x0
Xsecondstage[1] vdd vss secondstage[1] secondstage[2] inv_x0
Xsecondstage[2] vdd vss secondstage[2] secondstage[3] inv_x0
Xsecondstage[3] vdd vss secondstage[3] secondstage[4] inv_x0
.ends SP6T3NonOvlClock_4S11341D1R

.subckt SP6T3ClockGen_4S11341D1R vss vdd clk wl_en decodeclk columnclk precharge_n we_en
Xnonovl vss vdd clk firststage[0] firststage[1] firststage[2] firstpulse firststage[4] secondstage[0] secondstage[1] secondstage[2] secondpulse secondstage[4] SP6T3NonOvlClock_4S11341D1R
Xdecodeclkbuf vdd vss clk decodeclk buf_x1
Xcolumnclkbuf vdd vss clk columnclk buf_x1
Xprechargeinv vdd vss secondpulse precharge_n inv_x3
Xwlenbuf vdd vss firstpulse wl_en buf_x4
Xweenbuf vdd vss firstpulse we_en buf_x1
.ends SP6T3ClockGen_4S11341D1R

.subckt SP6T3DirectColDec_A2B2R vss vdd clk a[0] a[1] line[0] line[1] line[2] line[3]
Xaff[0] vdd vss a[0] clk aint[0] SP6T1Dec_dff_x1
Xaff[1] vdd vss a[1] clk aint[1] SP6T1Dec_dff_x1
Xainv[0] vdd vss aint[0] aint_n[0] SP6T1Dec_inv_x1
Xainv[1] vdd vss aint[1] aint_n[1] SP6T1Dec_inv_x1
Xlinenand[0] vdd vss line_n[0] aint_n[0] aint_n[1] SP6T1Dec_nand2_x0
Xlinenand[1] vdd vss line_n[1] aint[0] aint_n[1] SP6T1Dec_nand2_x0
Xlinenand[2] vdd vss line_n[2] aint_n[0] aint[1] SP6T1Dec_nand2_x0
Xlinenand[3] vdd vss line_n[3] aint[0] aint[1] SP6T1Dec_nand2_x0
Xlineinv[0] vdd vss line_n[0] line[0] SP6T1Dec_inv_x2
Xlineinv[1] vdd vss line_n[1] line[1] SP6T1Dec_inv_x2
Xlineinv[2] vdd vss line_n[2] line[2] SP6T1Dec_inv_x2
Xlineinv[3] vdd vss line_n[3] line[3] SP6T1Dec_inv_x2
.ends SP6T3DirectColDec_A2B2R

.subckt SP6T3RowPredecoders_A3B4B vss vdd clk a[0] a[1] a[2] a[3] a[4] a[5] a[6] pd[0][0] pd[0][1] pd[0][2] pd[0][3] pd[0][4] pd[0][5] pd[0][6] pd[0][7] page[0] page[1] page[2] page[3] page[4] page[5] page[6] page[7] page[8] page[9] page[10] page[11] page[12] page[13] page[14] page[15]
Xaff[0] vdd vss a[0] clk aint[0] SP6T1Dec_dff_x1
Xaff[1] vdd vss a[1] clk aint[1] SP6T1Dec_dff_x1
Xaff[2] vdd vss a[2] clk aint[2] SP6T1Dec_dff_x1
Xaff[3] vdd vss a[3] clk aint[3] SP6T1Dec_dff_x1
Xaff[4] vdd vss a[4] clk aint[4] SP6T1Dec_dff_x1
Xaff[5] vdd vss a[5] clk aint[5] SP6T1Dec_dff_x1
Xaff[6] vdd vss a[6] clk aint[6] SP6T1Dec_dff_x1
Xainv[0] vdd vss aint[0] aint_n[0] SP6T1Dec_inv_x1
Xainv[1] vdd vss aint[1] aint_n[1] SP6T1Dec_inv_x1
Xainv[2] vdd vss aint[2] aint_n[2] SP6T1Dec_inv_x1
Xainv[3] vdd vss aint[3] aint_n[3] SP6T1Dec_inv_x1
Xainv[4] vdd vss aint[4] aint_n[4] SP6T1Dec_inv_x1
Xainv[5] vdd vss aint[5] aint_n[5] SP6T1Dec_inv_x1
Xainv[6] vdd vss aint[6] aint_n[6] SP6T1Dec_inv_x1
Xpd[0]and[0] vdd vss pd[0][0] aint_n[0] aint_n[1] aint_n[2] SP6T1Dec_and3_x1
Xpd[0]and[1] vdd vss pd[0][1] aint[0] aint_n[1] aint_n[2] SP6T1Dec_and3_x1
Xpd[0]and[2] vdd vss pd[0][2] aint_n[0] aint[1] aint_n[2] SP6T1Dec_and3_x1
Xpd[0]and[3] vdd vss pd[0][3] aint[0] aint[1] aint_n[2] SP6T1Dec_and3_x1
Xpd[0]and[4] vdd vss pd[0][4] aint_n[0] aint_n[1] aint[2] SP6T1Dec_and3_x1
Xpd[0]and[5] vdd vss pd[0][5] aint[0] aint_n[1] aint[2] SP6T1Dec_and3_x1
Xpd[0]and[6] vdd vss pd[0][6] aint_n[0] aint[1] aint[2] SP6T1Dec_and3_x1
Xpd[0]and[7] vdd vss pd[0][7] aint[0] aint[1] aint[2] SP6T1Dec_and3_x1
Xpage_and[0] vdd vss page[0] aint_n[3] aint_n[4] aint_n[5] aint_n[6] SP6T1Dec_and4_x1
Xpage_and[1] vdd vss page[1] aint[3] aint_n[4] aint_n[5] aint_n[6] SP6T1Dec_and4_x1
Xpage_and[2] vdd vss page[2] aint_n[3] aint[4] aint_n[5] aint_n[6] SP6T1Dec_and4_x1
Xpage_and[3] vdd vss page[3] aint[3] aint[4] aint_n[5] aint_n[6] SP6T1Dec_and4_x1
Xpage_and[4] vdd vss page[4] aint_n[3] aint_n[4] aint[5] aint_n[6] SP6T1Dec_and4_x1
Xpage_and[5] vdd vss page[5] aint[3] aint_n[4] aint[5] aint_n[6] SP6T1Dec_and4_x1
Xpage_and[6] vdd vss page[6] aint_n[3] aint[4] aint[5] aint_n[6] SP6T1Dec_and4_x1
Xpage_and[7] vdd vss page[7] aint[3] aint[4] aint[5] aint_n[6] SP6T1Dec_and4_x1
Xpage_and[8] vdd vss page[8] aint_n[3] aint_n[4] aint_n[5] aint[6] SP6T1Dec_and4_x1
Xpage_and[9] vdd vss page[9] aint[3] aint_n[4] aint_n[5] aint[6] SP6T1Dec_and4_x1
Xpage_and[10] vdd vss page[10] aint_n[3] aint[4] aint_n[5] aint[6] SP6T1Dec_and4_x1
Xpage_and[11] vdd vss page[11] aint[3] aint[4] aint_n[5] aint[6] SP6T1Dec_and4_x1
Xpage_and[12] vdd vss page[12] aint_n[3] aint_n[4] aint[5] aint[6] SP6T1Dec_and4_x1
Xpage_and[13] vdd vss page[13] aint[3] aint_n[4] aint[5] aint[6] SP6T1Dec_and4_x1
Xpage_and[14] vdd vss page[14] aint_n[3] aint[4] aint[5] aint[6] SP6T1Dec_and4_x1
Xpage_and[15] vdd vss page[15] aint[3] aint[4] aint[5] aint[6] SP6T1Dec_and4_x1
Xtie[0] vdd vss SP6T1Dec_tie_diff_w4
Xtie[1] vdd vss SP6T1Dec_tie_diff_w4
Xtie[2] vdd vss SP6T1Dec_tie_diff_w4
Xtie[3] vdd vss SP6T1Dec_tie_diff_w4
Xtie[4] vdd vss SP6T1Dec_tie_diff_w4
Xtie[5] vdd vss SP6T1Dec_tie_diff_w4
Xtie[6] vdd vss SP6T1Dec_tie_diff_w4
Xtie[7] vdd vss SP6T1Dec_tie_diff_w4
Xtie[8] vdd vss SP6T1Dec_tie_diff_w4
Xtie[9] vdd vss SP6T1Dec_tie_diff_w4
Xtie[10] vdd vss SP6T1Dec_tie_diff_w4
Xtie[11] vdd vss SP6T1Dec_tie_diff_w4
Xtie[12] vdd vss SP6T1Dec_tie_diff_w4
Xtie[13] vdd vss SP6T1Dec_tie_diff_w4
Xtie[14] vdd vss SP6T1Dec_tie_diff_w4
Xtie[15] vdd vss SP6T1Dec_tie_diff_w4
Xtie[16] vdd vss SP6T1Dec_tie_diff_w4
Xtie[17] vdd vss SP6T1Dec_tie_diff_w4
Xtie[18] vdd vss SP6T1Dec_tie_diff_w4
Xtie[19] vdd vss SP6T1Dec_tie_diff_w4
Xtie[20] vdd vss SP6T1Dec_tie_diff_w4
Xtie[21] vdd vss SP6T1Dec_tie_diff_w4
Xtie[22] vdd vss SP6T1Dec_tie_diff_w4
Xtie[23] vdd vss SP6T1Dec_tie_diff_w4
Xtie[24] vdd vss SP6T1Dec_tie_diff_w4
Xtie[25] vdd vss SP6T1Dec_tie_diff_w4
Xtie[25] vdd vss SP6T1Dec_tie_diff_w4
Xtie[25] vdd vss SP6T1Dec_tie_diff_w4
Xtie[25] vdd vss SP6T1Dec_tie_diff_w4
Xtie[25] vdd vss SP6T1Dec_tie_diff_w4
Xtie[25] vdd vss SP6T1Dec_tie_diff_w4
Xtie[25] vdd vss SP6T1Dec_tie_diff_w4
Xtie[25] vdd vss SP6T1Dec_tie_diff_w4
Xtie[25] vdd vss SP6T1Dec_tie_diff_w4
Xtie[25] vdd vss SP6T1Dec_tie_diff_w4
Xtie[25] vdd vss SP6T1Dec_tie_diff_w4
Xtie[25] vdd vss SP6T1Dec_tie_diff_w4
Xtie[25] vdd vss SP6T1Dec_tie_diff_w4
Xtie[25] vdd vss SP6T1Dec_tie_diff_w4
Xtie[25] vdd vss SP6T1Dec_tie_diff_w4
Xtie[25] vdd vss SP6T1Dec_tie_diff_w4
Xtie[25] vdd vss SP6T1Dec_tie_diff_w4
Xtie[25] vdd vss SP6T1Dec_tie_diff_w4
Xtie[25] vdd vss SP6T1Dec_tie_diff_w4
Xtie[25] vdd vss SP6T1Dec_tie_diff_w4
Xtie[25] vdd vss SP6T1Dec_tie_diff_w4
Xtie[25] vdd vss SP6T1Dec_tie_diff_w4
.ends SP6T3RowPredecoders_A3B4B

.subckt SP6T3RowDecoderNand3X2 vss vdd pd[0][0] pd[0][1] page wl_en wl_n[0] wl_n[1]
Xnmos[0] wl_n[0] wl_en int[0] vss sg13_lv_nmos l=1.3e-07 w=4.9e-07
Xnmos[1] int[0] pd[0][0] int[1] vss sg13_lv_nmos l=1.3e-07 w=4.9e-07
Xnmos[2] int[1] page vss vss sg13_lv_nmos l=1.3e-07 w=4.9e-07
Xnmos[3] vss page int[2] vss sg13_lv_nmos l=1.3e-07 w=4.9e-07
Xnmos[4] int[2] pd[0][1] int[3] vss sg13_lv_nmos l=1.3e-07 w=4.9e-07
Xnmos[5] int[3] wl_en wl_n[1] vss sg13_lv_nmos l=1.3e-07 w=4.9e-07
Xpmos[0] wl_n[0] wl_en vdd vdd sg13_lv_pmos l=1.3e-07 w=4.9e-07
Xpmos[1] vdd pd[0][0] wl_n[0] vdd sg13_lv_pmos l=1.3e-07 w=4.9e-07
Xpmos[2] wl_n[0] page vdd vdd sg13_lv_pmos l=1.3e-07 w=4.9e-07
Xpmos[3] vdd page wl_n[1] vdd sg13_lv_pmos l=1.3e-07 w=4.9e-07
Xpmos[4] wl_n[1] pd[0][1] vdd vdd sg13_lv_pmos l=1.3e-07 w=4.9e-07
Xpmos[5] vdd wl_en wl_n[1] vdd sg13_lv_pmos l=1.3e-07 w=4.9e-07
.ends SP6T3RowDecoderNand3X2

.subckt SP6T3RowDecPage_PD3B4BDH vss vdd pd[0][0] pd[0][1] wl_n[0] wl_n[1] pd[0][2] pd[0][3] wl_n[2] wl_n[3] pd[0][4] pd[0][5] wl_n[4] wl_n[5] pd[0][6] pd[0][7] wl_n[6] wl_n[7] page wl_en
Xnand3[0] vss vdd pd[0][0] pd[0][1] page wl_en wl_n[0] wl_n[1] SP6T3RowDecoderNand3X2
Xnand3[1] vss vdd pd[0][2] pd[0][3] page wl_en wl_n[2] wl_n[3] SP6T3RowDecoderNand3X2
Xnand3[2] vss vdd pd[0][4] pd[0][5] page wl_en wl_n[4] wl_n[5] SP6T3RowDecoderNand3X2
Xnand3[3] vss vdd pd[0][6] pd[0][7] page wl_en wl_n[6] wl_n[7] SP6T3RowDecoderNand3X2
.ends SP6T3RowDecPage_PD3B4BDH

.subckt SP6T3RowDecLastStageBC_N3DH vss vdd
.ends SP6T3RowDecLastStageBC_N3DH

.subckt SP6T3RowDec_PD3B4B_PAG3B4B0 vss vdd a[0] a[1] a[2] a[3] a[4] a[5] a[6] clk wl_en wl_n[0] wl_n[1] wl_n[2] wl_n[3] wl_n[4] wl_n[5] wl_n[6] wl_n[7] wl_n[8] wl_n[9] wl_n[10] wl_n[11] wl_n[12] wl_n[13] wl_n[14] wl_n[15] wl_n[16] wl_n[17] wl_n[18] wl_n[19] wl_n[20] wl_n[21] wl_n[22] wl_n[23] wl_n[24] wl_n[25] wl_n[26] wl_n[27] wl_n[28] wl_n[29] wl_n[30] wl_n[31] wl_n[32] wl_n[33] wl_n[34] wl_n[35] wl_n[36] wl_n[37] wl_n[38] wl_n[39] wl_n[40] wl_n[41] wl_n[42] wl_n[43] wl_n[44] wl_n[45] wl_n[46] wl_n[47] wl_n[48] wl_n[49] wl_n[50] wl_n[51] wl_n[52] wl_n[53] wl_n[54] wl_n[55] wl_n[56] wl_n[57] wl_n[58] wl_n[59] wl_n[60] wl_n[61] wl_n[62] wl_n[63] wl_n[64] wl_n[65] wl_n[66] wl_n[67] wl_n[68] wl_n[69] wl_n[70] wl_n[71] wl_n[72] wl_n[73] wl_n[74] wl_n[75] wl_n[76] wl_n[77] wl_n[78] wl_n[79] wl_n[80] wl_n[81] wl_n[82] wl_n[83] wl_n[84] wl_n[85] wl_n[86] wl_n[87] wl_n[88] wl_n[89] wl_n[90] wl_n[91] wl_n[92] wl_n[93] wl_n[94] wl_n[95] wl_n[96] wl_n[97] wl_n[98] wl_n[99] wl_n[100] wl_n[101] wl_n[102] wl_n[103] wl_n[104] wl_n[105] wl_n[106] wl_n[107] wl_n[108] wl_n[109] wl_n[110] wl_n[111] wl_n[112] wl_n[113] wl_n[114] wl_n[115] wl_n[116] wl_n[117] wl_n[118] wl_n[119] wl_n[120] wl_n[121] wl_n[122] wl_n[123] wl_n[124] wl_n[125] wl_n[126] wl_n[127]
Xpredec vss vdd clk a[0] a[1] a[2] a[3] a[4] a[5] a[6] pd[0][0] pd[0][1] pd[0][2] pd[0][3] pd[0][4] pd[0][5] pd[0][6] pd[0][7] page[0] page[1] page[2] page[3] page[4] page[5] page[6] page[7] page[8] page[9] page[10] page[11] page[12] page[13] page[14] page[15] SP6T3RowPredecoders_A3B4B
Xpage[0] vss vdd pd[0][0] pd[0][1] wl_n[0] wl_n[1] pd[0][2] pd[0][3] wl_n[2] wl_n[3] pd[0][4] pd[0][5] wl_n[4] wl_n[5] pd[0][6] pd[0][7] wl_n[6] wl_n[7] page[0] wl_en SP6T3RowDecPage_PD3B4BDH
Xpage[1] vss vdd pd[0][0] pd[0][1] wl_n[8] wl_n[9] pd[0][2] pd[0][3] wl_n[10] wl_n[11] pd[0][4] pd[0][5] wl_n[12] wl_n[13] pd[0][6] pd[0][7] wl_n[14] wl_n[15] page[1] wl_en SP6T3RowDecPage_PD3B4BDH
Xpage[2] vss vdd pd[0][0] pd[0][1] wl_n[16] wl_n[17] pd[0][2] pd[0][3] wl_n[18] wl_n[19] pd[0][4] pd[0][5] wl_n[20] wl_n[21] pd[0][6] pd[0][7] wl_n[22] wl_n[23] page[2] wl_en SP6T3RowDecPage_PD3B4BDH
Xpage[3] vss vdd pd[0][0] pd[0][1] wl_n[24] wl_n[25] pd[0][2] pd[0][3] wl_n[26] wl_n[27] pd[0][4] pd[0][5] wl_n[28] wl_n[29] pd[0][6] pd[0][7] wl_n[30] wl_n[31] page[3] wl_en SP6T3RowDecPage_PD3B4BDH
Xpage[4] vss vdd pd[0][0] pd[0][1] wl_n[32] wl_n[33] pd[0][2] pd[0][3] wl_n[34] wl_n[35] pd[0][4] pd[0][5] wl_n[36] wl_n[37] pd[0][6] pd[0][7] wl_n[38] wl_n[39] page[4] wl_en SP6T3RowDecPage_PD3B4BDH
Xpage[5] vss vdd pd[0][0] pd[0][1] wl_n[40] wl_n[41] pd[0][2] pd[0][3] wl_n[42] wl_n[43] pd[0][4] pd[0][5] wl_n[44] wl_n[45] pd[0][6] pd[0][7] wl_n[46] wl_n[47] page[5] wl_en SP6T3RowDecPage_PD3B4BDH
Xpage[6] vss vdd pd[0][0] pd[0][1] wl_n[48] wl_n[49] pd[0][2] pd[0][3] wl_n[50] wl_n[51] pd[0][4] pd[0][5] wl_n[52] wl_n[53] pd[0][6] pd[0][7] wl_n[54] wl_n[55] page[6] wl_en SP6T3RowDecPage_PD3B4BDH
Xpage[7] vss vdd pd[0][0] pd[0][1] wl_n[56] wl_n[57] pd[0][2] pd[0][3] wl_n[58] wl_n[59] pd[0][4] pd[0][5] wl_n[60] wl_n[61] pd[0][6] pd[0][7] wl_n[62] wl_n[63] page[7] wl_en SP6T3RowDecPage_PD3B4BDH
Xpage[8] vss vdd pd[0][0] pd[0][1] wl_n[64] wl_n[65] pd[0][2] pd[0][3] wl_n[66] wl_n[67] pd[0][4] pd[0][5] wl_n[68] wl_n[69] pd[0][6] pd[0][7] wl_n[70] wl_n[71] page[8] wl_en SP6T3RowDecPage_PD3B4BDH
Xpage[9] vss vdd pd[0][0] pd[0][1] wl_n[72] wl_n[73] pd[0][2] pd[0][3] wl_n[74] wl_n[75] pd[0][4] pd[0][5] wl_n[76] wl_n[77] pd[0][6] pd[0][7] wl_n[78] wl_n[79] page[9] wl_en SP6T3RowDecPage_PD3B4BDH
Xpage[10] vss vdd pd[0][0] pd[0][1] wl_n[80] wl_n[81] pd[0][2] pd[0][3] wl_n[82] wl_n[83] pd[0][4] pd[0][5] wl_n[84] wl_n[85] pd[0][6] pd[0][7] wl_n[86] wl_n[87] page[10] wl_en SP6T3RowDecPage_PD3B4BDH
Xpage[11] vss vdd pd[0][0] pd[0][1] wl_n[88] wl_n[89] pd[0][2] pd[0][3] wl_n[90] wl_n[91] pd[0][4] pd[0][5] wl_n[92] wl_n[93] pd[0][6] pd[0][7] wl_n[94] wl_n[95] page[11] wl_en SP6T3RowDecPage_PD3B4BDH
Xpage[12] vss vdd pd[0][0] pd[0][1] wl_n[96] wl_n[97] pd[0][2] pd[0][3] wl_n[98] wl_n[99] pd[0][4] pd[0][5] wl_n[100] wl_n[101] pd[0][6] pd[0][7] wl_n[102] wl_n[103] page[12] wl_en SP6T3RowDecPage_PD3B4BDH
Xpage[13] vss vdd pd[0][0] pd[0][1] wl_n[104] wl_n[105] pd[0][2] pd[0][3] wl_n[106] wl_n[107] pd[0][4] pd[0][5] wl_n[108] wl_n[109] pd[0][6] pd[0][7] wl_n[110] wl_n[111] page[13] wl_en SP6T3RowDecPage_PD3B4BDH
Xpage[14] vss vdd pd[0][0] pd[0][1] wl_n[112] wl_n[113] pd[0][2] pd[0][3] wl_n[114] wl_n[115] pd[0][4] pd[0][5] wl_n[116] wl_n[117] pd[0][6] pd[0][7] wl_n[118] wl_n[119] page[14] wl_en SP6T3RowDecPage_PD3B4BDH
Xpage[15] vss vdd pd[0][0] pd[0][1] wl_n[120] wl_n[121] pd[0][2] pd[0][3] wl_n[122] wl_n[123] pd[0][4] pd[0][5] wl_n[124] wl_n[125] pd[0][6] pd[0][7] wl_n[126] wl_n[127] page[15] wl_en SP6T3RowDecPage_PD3B4BDH
Xbulkcon[0] vss vdd SP6T3RowDecLastStageBC_N3DH
Xbulkcon[1] vss vdd SP6T3RowDecLastStageBC_N3DH
Xbulkcon[2] vss vdd SP6T3RowDecLastStageBC_N3DH
Xbulkcon[3] vss vdd SP6T3RowDecLastStageBC_N3DH
Xbulkcon[4] vss vdd SP6T3RowDecLastStageBC_N3DH
Xbulkcon[5] vss vdd SP6T3RowDecLastStageBC_N3DH
Xbulkcon[6] vss vdd SP6T3RowDecLastStageBC_N3DH
Xbulkcon[7] vss vdd SP6T3RowDecLastStageBC_N3DH
Xbulkcon[8] vss vdd SP6T3RowDecLastStageBC_N3DH
.ends SP6T3RowDec_PD3B4B_PAG3B4B0

.subckt SP6T3RowPeriph_PD3B4B_LD2B2R vss vdd a[0] a[1] a[2] a[3] a[4] a[5] a[6] a[7] a[8] wl_n[0] wl_n[1] wl_n[2] wl_n[3] wl_n[4] wl_n[5] wl_n[6] wl_n[7] wl_n[8] wl_n[9] wl_n[10] wl_n[11] wl_n[12] wl_n[13] wl_n[14] wl_n[15] wl_n[16] wl_n[17] wl_n[18] wl_n[19] wl_n[20] wl_n[21] wl_n[22] wl_n[23] wl_n[24] wl_n[25] wl_n[26] wl_n[27] wl_n[28] wl_n[29] wl_n[30] wl_n[31] wl_n[32] wl_n[33] wl_n[34] wl_n[35] wl_n[36] wl_n[37] wl_n[38] wl_n[39] wl_n[40] wl_n[41] wl_n[42] wl_n[43] wl_n[44] wl_n[45] wl_n[46] wl_n[47] wl_n[48] wl_n[49] wl_n[50] wl_n[51] wl_n[52] wl_n[53] wl_n[54] wl_n[55] wl_n[56] wl_n[57] wl_n[58] wl_n[59] wl_n[60] wl_n[61] wl_n[62] wl_n[63] wl_n[64] wl_n[65] wl_n[66] wl_n[67] wl_n[68] wl_n[69] wl_n[70] wl_n[71] wl_n[72] wl_n[73] wl_n[74] wl_n[75] wl_n[76] wl_n[77] wl_n[78] wl_n[79] wl_n[80] wl_n[81] wl_n[82] wl_n[83] wl_n[84] wl_n[85] wl_n[86] wl_n[87] wl_n[88] wl_n[89] wl_n[90] wl_n[91] wl_n[92] wl_n[93] wl_n[94] wl_n[95] wl_n[96] wl_n[97] wl_n[98] wl_n[99] wl_n[100] wl_n[101] wl_n[102] wl_n[103] wl_n[104] wl_n[105] wl_n[106] wl_n[107] wl_n[108] wl_n[109] wl_n[110] wl_n[111] wl_n[112] wl_n[113] wl_n[114] wl_n[115] wl_n[116] wl_n[117] wl_n[118] wl_n[119] wl_n[120] wl_n[121] wl_n[122] wl_n[123] wl_n[124] wl_n[125] wl_n[126] wl_n[127] decodeclk wl_en mux[0] mux[1] mux[2] mux[3]
Xcoldec vss vdd decodeclk a[0] a[1] mux[0] mux[1] mux[2] mux[3] SP6T3DirectColDec_A2B2R
Xrowdec vss vdd a[2] a[3] a[4] a[5] a[6] a[7] a[8] decodeclk wl_en wl_n[0] wl_n[1] wl_n[2] wl_n[3] wl_n[4] wl_n[5] wl_n[6] wl_n[7] wl_n[8] wl_n[9] wl_n[10] wl_n[11] wl_n[12] wl_n[13] wl_n[14] wl_n[15] wl_n[16] wl_n[17] wl_n[18] wl_n[19] wl_n[20] wl_n[21] wl_n[22] wl_n[23] wl_n[24] wl_n[25] wl_n[26] wl_n[27] wl_n[28] wl_n[29] wl_n[30] wl_n[31] wl_n[32] wl_n[33] wl_n[34] wl_n[35] wl_n[36] wl_n[37] wl_n[38] wl_n[39] wl_n[40] wl_n[41] wl_n[42] wl_n[43] wl_n[44] wl_n[45] wl_n[46] wl_n[47] wl_n[48] wl_n[49] wl_n[50] wl_n[51] wl_n[52] wl_n[53] wl_n[54] wl_n[55] wl_n[56] wl_n[57] wl_n[58] wl_n[59] wl_n[60] wl_n[61] wl_n[62] wl_n[63] wl_n[64] wl_n[65] wl_n[66] wl_n[67] wl_n[68] wl_n[69] wl_n[70] wl_n[71] wl_n[72] wl_n[73] wl_n[74] wl_n[75] wl_n[76] wl_n[77] wl_n[78] wl_n[79] wl_n[80] wl_n[81] wl_n[82] wl_n[83] wl_n[84] wl_n[85] wl_n[86] wl_n[87] wl_n[88] wl_n[89] wl_n[90] wl_n[91] wl_n[92] wl_n[93] wl_n[94] wl_n[95] wl_n[96] wl_n[97] wl_n[98] wl_n[99] wl_n[100] wl_n[101] wl_n[102] wl_n[103] wl_n[104] wl_n[105] wl_n[106] wl_n[107] wl_n[108] wl_n[109] wl_n[110] wl_n[111] wl_n[112] wl_n[113] wl_n[114] wl_n[115] wl_n[116] wl_n[117] wl_n[118] wl_n[119] wl_n[120] wl_n[121] wl_n[122] wl_n[123] wl_n[124] wl_n[125] wl_n[126] wl_n[127] SP6T3RowDec_PD3B4B_PAG3B4B0
.ends SP6T3RowPeriph_PD3B4B_LD2B2R

.subckt SP6T3Block_512x32_4we_C2B_R3B4B clk a[0] a[1] a[2] a[3] a[4] a[5] a[6] a[7] a[8] vss vdd q[0] q[1] q[2] q[3] q[4] q[5] q[6] q[7] q[8] q[9] q[10] q[11] q[12] q[13] q[14] q[15] q[16] q[17] q[18] q[19] q[20] q[21] q[22] q[23] q[24] q[25] q[26] q[27] q[28] q[29] q[30] q[31] d[0] d[1] d[2] d[3] d[4] d[5] d[6] d[7] d[8] d[9] d[10] d[11] d[12] d[13] d[14] d[15] d[16] d[17] d[18] d[19] d[20] d[21] d[22] d[23] d[24] d[25] d[26] d[27] d[28] d[29] d[30] d[31] we[0] we[1] we[2] we[3]
Xcolumnblock vss vdd columnclk precharge_n we_en wl[0] wl[1] wl[2] wl[3] wl[4] wl[5] wl[6] wl[7] wl[8] wl[9] wl[10] wl[11] wl[12] wl[13] wl[14] wl[15] wl[16] wl[17] wl[18] wl[19] wl[20] wl[21] wl[22] wl[23] wl[24] wl[25] wl[26] wl[27] wl[28] wl[29] wl[30] wl[31] wl[32] wl[33] wl[34] wl[35] wl[36] wl[37] wl[38] wl[39] wl[40] wl[41] wl[42] wl[43] wl[44] wl[45] wl[46] wl[47] wl[48] wl[49] wl[50] wl[51] wl[52] wl[53] wl[54] wl[55] wl[56] wl[57] wl[58] wl[59] wl[60] wl[61] wl[62] wl[63] wl[64] wl[65] wl[66] wl[67] wl[68] wl[69] wl[70] wl[71] wl[72] wl[73] wl[74] wl[75] wl[76] wl[77] wl[78] wl[79] wl[80] wl[81] wl[82] wl[83] wl[84] wl[85] wl[86] wl[87] wl[88] wl[89] wl[90] wl[91] wl[92] wl[93] wl[94] wl[95] wl[96] wl[97] wl[98] wl[99] wl[100] wl[101] wl[102] wl[103] wl[104] wl[105] wl[106] wl[107] wl[108] wl[109] wl[110] wl[111] wl[112] wl[113] wl[114] wl[115] wl[116] wl[117] wl[118] wl[119] wl[120] wl[121] wl[122] wl[123] wl[124] wl[125] wl[126] wl[127] mux[0] mux[1] mux[2] mux[3] we[0] q[0] d[0] q[1] d[1] q[2] d[2] q[3] d[3] q[4] d[4] q[5] d[5] q[6] d[6] q[7] d[7] we[1] q[8] d[8] q[9] d[9] q[10] d[10] q[11] d[11] q[12] d[12] q[13] d[13] q[14] d[14] q[15] d[15] we[2] q[16] d[16] q[17] d[17] q[18] d[18] q[19] d[19] q[20] d[20] q[21] d[21] q[22] d[22] q[23] d[23] we[3] q[24] d[24] q[25] d[25] q[26] d[26] q[27] d[27] q[28] d[28] q[29] d[29] q[30] d[30] q[31] d[31] SP6T3ColumnBlock_COL128R_CP8B_CM4MN26L580W1R_PC26L100W_4WE
Xwldrivercol vss vdd wl[0] wl_n[0] wl[1] wl_n[1] wl[2] wl_n[2] wl[3] wl_n[3] wl[4] wl_n[4] wl[5] wl_n[5] wl[6] wl_n[6] wl[7] wl_n[7] wl[8] wl_n[8] wl[9] wl_n[9] wl[10] wl_n[10] wl[11] wl_n[11] wl[12] wl_n[12] wl[13] wl_n[13] wl[14] wl_n[14] wl[15] wl_n[15] wl[16] wl_n[16] wl[17] wl_n[17] wl[18] wl_n[18] wl[19] wl_n[19] wl[20] wl_n[20] wl[21] wl_n[21] wl[22] wl_n[22] wl[23] wl_n[23] wl[24] wl_n[24] wl[25] wl_n[25] wl[26] wl_n[26] wl[27] wl_n[27] wl[28] wl_n[28] wl[29] wl_n[29] wl[30] wl_n[30] wl[31] wl_n[31] wl[32] wl_n[32] wl[33] wl_n[33] wl[34] wl_n[34] wl[35] wl_n[35] wl[36] wl_n[36] wl[37] wl_n[37] wl[38] wl_n[38] wl[39] wl_n[39] wl[40] wl_n[40] wl[41] wl_n[41] wl[42] wl_n[42] wl[43] wl_n[43] wl[44] wl_n[44] wl[45] wl_n[45] wl[46] wl_n[46] wl[47] wl_n[47] wl[48] wl_n[48] wl[49] wl_n[49] wl[50] wl_n[50] wl[51] wl_n[51] wl[52] wl_n[52] wl[53] wl_n[53] wl[54] wl_n[54] wl[55] wl_n[55] wl[56] wl_n[56] wl[57] wl_n[57] wl[58] wl_n[58] wl[59] wl_n[59] wl[60] wl_n[60] wl[61] wl_n[61] wl[62] wl_n[62] wl[63] wl_n[63] wl[64] wl_n[64] wl[65] wl_n[65] wl[66] wl_n[66] wl[67] wl_n[67] wl[68] wl_n[68] wl[69] wl_n[69] wl[70] wl_n[70] wl[71] wl_n[71] wl[72] wl_n[72] wl[73] wl_n[73] wl[74] wl_n[74] wl[75] wl_n[75] wl[76] wl_n[76] wl[77] wl_n[77] wl[78] wl_n[78] wl[79] wl_n[79] wl[80] wl_n[80] wl[81] wl_n[81] wl[82] wl_n[82] wl[83] wl_n[83] wl[84] wl_n[84] wl[85] wl_n[85] wl[86] wl_n[86] wl[87] wl_n[87] wl[88] wl_n[88] wl[89] wl_n[89] wl[90] wl_n[90] wl[91] wl_n[91] wl[92] wl_n[92] wl[93] wl_n[93] wl[94] wl_n[94] wl[95] wl_n[95] wl[96] wl_n[96] wl[97] wl_n[97] wl[98] wl_n[98] wl[99] wl_n[99] wl[100] wl_n[100] wl[101] wl_n[101] wl[102] wl_n[102] wl[103] wl_n[103] wl[104] wl_n[104] wl[105] wl_n[105] wl[106] wl_n[106] wl[107] wl_n[107] wl[108] wl_n[108] wl[109] wl_n[109] wl[110] wl_n[110] wl[111] wl_n[111] wl[112] wl_n[112] wl[113] wl_n[113] wl[114] wl_n[114] wl[115] wl_n[115] wl[116] wl_n[116] wl[117] wl_n[117] wl[118] wl_n[118] wl[119] wl_n[119] wl[120] wl_n[120] wl[121] wl_n[121] wl[122] wl_n[122] wl[123] wl_n[123] wl[124] wl_n[124] wl[125] wl_n[125] wl[126] wl_n[126] wl[127] wl_n[127] SP6T3WLDriverCol_128RN26L400WP26L800W
Xclkgen vss vdd clk wl_en decodeclk columnclk precharge_n we_en SP6T3ClockGen_4S11341D1R
Xrowperiph vss vdd a[0] a[1] a[2] a[3] a[4] a[5] a[6] a[7] a[8] wl_n[0] wl_n[1] wl_n[2] wl_n[3] wl_n[4] wl_n[5] wl_n[6] wl_n[7] wl_n[8] wl_n[9] wl_n[10] wl_n[11] wl_n[12] wl_n[13] wl_n[14] wl_n[15] wl_n[16] wl_n[17] wl_n[18] wl_n[19] wl_n[20] wl_n[21] wl_n[22] wl_n[23] wl_n[24] wl_n[25] wl_n[26] wl_n[27] wl_n[28] wl_n[29] wl_n[30] wl_n[31] wl_n[32] wl_n[33] wl_n[34] wl_n[35] wl_n[36] wl_n[37] wl_n[38] wl_n[39] wl_n[40] wl_n[41] wl_n[42] wl_n[43] wl_n[44] wl_n[45] wl_n[46] wl_n[47] wl_n[48] wl_n[49] wl_n[50] wl_n[51] wl_n[52] wl_n[53] wl_n[54] wl_n[55] wl_n[56] wl_n[57] wl_n[58] wl_n[59] wl_n[60] wl_n[61] wl_n[62] wl_n[63] wl_n[64] wl_n[65] wl_n[66] wl_n[67] wl_n[68] wl_n[69] wl_n[70] wl_n[71] wl_n[72] wl_n[73] wl_n[74] wl_n[75] wl_n[76] wl_n[77] wl_n[78] wl_n[79] wl_n[80] wl_n[81] wl_n[82] wl_n[83] wl_n[84] wl_n[85] wl_n[86] wl_n[87] wl_n[88] wl_n[89] wl_n[90] wl_n[91] wl_n[92] wl_n[93] wl_n[94] wl_n[95] wl_n[96] wl_n[97] wl_n[98] wl_n[99] wl_n[100] wl_n[101] wl_n[102] wl_n[103] wl_n[104] wl_n[105] wl_n[106] wl_n[107] wl_n[108] wl_n[109] wl_n[110] wl_n[111] wl_n[112] wl_n[113] wl_n[114] wl_n[115] wl_n[116] wl_n[117] wl_n[118] wl_n[119] wl_n[120] wl_n[121] wl_n[122] wl_n[123] wl_n[124] wl_n[125] wl_n[126] wl_n[127] decodeclk wl_en mux[0] mux[1] mux[2] mux[3] SP6T3RowPeriph_PD3B4B_LD2B2R
.ends SP6T3Block_512x32_4we_C2B_R3B4B

.subckt SP6T3TimingIn_9SF vss vdd sr_in sr_out sr_shift sr_latch i[8] i[7] i[6] i[5] i[4] i[3] i[2] i[1] i[0]
Xshiftff[8] vdd vss sr_in sr_shift i_s[8] dff_x1
Xshiftff[7] vdd vss i_s[8] sr_shift i_s[7] dff_x1
Xshiftff[6] vdd vss i_s[7] sr_shift i_s[6] dff_x1
Xshiftff[5] vdd vss i_s[6] sr_shift i_s[5] dff_x1
Xshiftff[4] vdd vss i_s[5] sr_shift i_s[4] dff_x1
Xshiftff[3] vdd vss i_s[4] sr_shift i_s[3] dff_x1
Xshiftff[2] vdd vss i_s[3] sr_shift i_s[2] dff_x1
Xshiftff[1] vdd vss i_s[2] sr_shift i_s[1] dff_x1
Xshiftff[0] vdd vss i_s[1] sr_shift sr_out dff_x1
Xlatchff[8] vdd vss i_s[8] sr_latch i[8] dff_x1
Xlatchff[7] vdd vss i_s[7] sr_latch i[7] dff_x1
Xlatchff[6] vdd vss i_s[6] sr_latch i[6] dff_x1
Xlatchff[5] vdd vss i_s[5] sr_latch i[5] dff_x1
Xlatchff[4] vdd vss i_s[4] sr_latch i[4] dff_x1
Xlatchff[3] vdd vss i_s[3] sr_latch i[3] dff_x1
Xlatchff[2] vdd vss i_s[2] sr_latch i[2] dff_x1
Xlatchff[1] vdd vss i_s[1] sr_latch i[1] dff_x1
Xlatchff[0] vdd vss sr_out sr_latch i[0] dff_x1
.ends SP6T3TimingIn_9SF

.subckt SP6T3TimingOut_2SL vss vdd sr_in sr_out sr_shift sr_latch l2s o[0] o[1]
Xshiftff[0] vdd vss o_m[0] sr_shift o_s[0] dff_x1
Xshiftff[1] vdd vss o_m[1] sr_shift sr_out dff_x1
Xlatchff[0] vdd vss o[0] sr_latch o_l[0] dff_x1
Xlatchff[1] vdd vss o[1] sr_latch o_l[1] dff_x1
Xmux[0] vdd vss sr_in o_l[0] l2s o_m[0] mux2_x1
Xmux[1] vdd vss o_s[0] o_l[1] l2s o_m[1] mux2_x1
.ends SP6T3TimingOut_2SL

.subckt SP6T3TimingIn_9SL vss vdd sr_in sr_out sr_shift sr_latch i[0] i[1] i[2] i[3] i[4] i[5] i[6] i[7] i[8]
Xshiftff[0] vdd vss sr_in sr_shift i_s[0] dff_x1
Xshiftff[1] vdd vss i_s[0] sr_shift i_s[1] dff_x1
Xshiftff[2] vdd vss i_s[1] sr_shift i_s[2] dff_x1
Xshiftff[3] vdd vss i_s[2] sr_shift i_s[3] dff_x1
Xshiftff[4] vdd vss i_s[3] sr_shift i_s[4] dff_x1
Xshiftff[5] vdd vss i_s[4] sr_shift i_s[5] dff_x1
Xshiftff[6] vdd vss i_s[5] sr_shift i_s[6] dff_x1
Xshiftff[7] vdd vss i_s[6] sr_shift i_s[7] dff_x1
Xshiftff[8] vdd vss i_s[7] sr_shift sr_out dff_x1
Xlatchff[0] vdd vss i_s[0] sr_latch i[0] dff_x1
Xlatchff[1] vdd vss i_s[1] sr_latch i[1] dff_x1
Xlatchff[2] vdd vss i_s[2] sr_latch i[2] dff_x1
Xlatchff[3] vdd vss i_s[3] sr_latch i[3] dff_x1
Xlatchff[4] vdd vss i_s[4] sr_latch i[4] dff_x1
Xlatchff[5] vdd vss i_s[5] sr_latch i[5] dff_x1
Xlatchff[6] vdd vss i_s[6] sr_latch i[6] dff_x1
Xlatchff[7] vdd vss i_s[7] sr_latch i[7] dff_x1
Xlatchff[8] vdd vss sr_out sr_latch i[8] dff_x1
.ends SP6T3TimingIn_9SL

.subckt SP6T3TimingOut_8SL vss vdd sr_in sr_out sr_shift sr_latch l2s o[0] o[1] o[2] o[3] o[4] o[5] o[6] o[7]
Xshiftff[0] vdd vss o_m[0] sr_shift o_s[0] dff_x1
Xshiftff[1] vdd vss o_m[1] sr_shift o_s[1] dff_x1
Xshiftff[2] vdd vss o_m[2] sr_shift o_s[2] dff_x1
Xshiftff[3] vdd vss o_m[3] sr_shift o_s[3] dff_x1
Xshiftff[4] vdd vss o_m[4] sr_shift o_s[4] dff_x1
Xshiftff[5] vdd vss o_m[5] sr_shift o_s[5] dff_x1
Xshiftff[6] vdd vss o_m[6] sr_shift o_s[6] dff_x1
Xshiftff[7] vdd vss o_m[7] sr_shift sr_out dff_x1
Xlatchff[0] vdd vss o[0] sr_latch o_l[0] dff_x1
Xlatchff[1] vdd vss o[1] sr_latch o_l[1] dff_x1
Xlatchff[2] vdd vss o[2] sr_latch o_l[2] dff_x1
Xlatchff[3] vdd vss o[3] sr_latch o_l[3] dff_x1
Xlatchff[4] vdd vss o[4] sr_latch o_l[4] dff_x1
Xlatchff[5] vdd vss o[5] sr_latch o_l[5] dff_x1
Xlatchff[6] vdd vss o[6] sr_latch o_l[6] dff_x1
Xlatchff[7] vdd vss o[7] sr_latch o_l[7] dff_x1
Xmux[0] vdd vss sr_in o_l[0] l2s o_m[0] mux2_x1
Xmux[1] vdd vss o_s[0] o_l[1] l2s o_m[1] mux2_x1
Xmux[2] vdd vss o_s[1] o_l[2] l2s o_m[2] mux2_x1
Xmux[3] vdd vss o_s[2] o_l[3] l2s o_m[3] mux2_x1
Xmux[4] vdd vss o_s[3] o_l[4] l2s o_m[4] mux2_x1
Xmux[5] vdd vss o_s[4] o_l[5] l2s o_m[5] mux2_x1
Xmux[6] vdd vss o_s[5] o_l[6] l2s o_m[6] mux2_x1
Xmux[7] vdd vss o_s[6] o_l[7] l2s o_m[7] mux2_x1
.ends SP6T3TimingOut_8SL

.subckt SP6T3Block_512x32_4we_C2B_R3B4B_Test vss vdd_block vdd_periph clk in_shift in_latch in_srin in_srout out_shift out_latch out_l2s out_srin out_srout
Xblock clk a[0] a[1] a[2] a[3] a[4] a[5] a[6] a[7] a[8] vss vdd_block q[0] q[1] q[2] q[3] q[4] q[5] q[6] q[7] q[8] q[9] q[10] q[11] q[12] q[13] q[14] q[15] q[16] q[17] q[18] q[19] q[20] q[21] q[22] q[23] q[24] q[25] q[26] q[27] q[28] q[29] q[30] q[31] d[0] d[1] d[2] d[3] d[4] d[5] d[6] d[7] d[8] d[9] d[10] d[11] d[12] d[13] d[14] d[15] d[16] d[17] d[18] d[19] d[20] d[21] d[22] d[23] d[24] d[25] d[26] d[27] d[28] d[29] d[30] d[31] we[0] we[1] we[2] we[3] SP6T3Block_512x32_4we_C2B_R3B4B
Xasr vss vdd_periph in_srin in_srconn[0] in_shift in_latch a[8] a[7] a[6] a[5] a[4] a[3] a[2] a[1] a[0] SP6T3TimingIn_9SF
Xclksr vss vdd_periph out_srin out_srconn[0] out_shift clk out_l2s in_latch out_latch SP6T3TimingOut_2SL
Xdwesr[0] vss vdd_periph in_srconn[0] in_srconn[1] in_shift in_latch d[0] d[1] d[2] d[3] d[4] d[5] d[6] d[7] we[0] SP6T3TimingIn_9SL
Xdwesr[1] vss vdd_periph in_srconn[1] in_srconn[2] in_shift in_latch d[8] d[9] d[10] d[11] d[12] d[13] d[14] d[15] we[1] SP6T3TimingIn_9SL
Xdwesr[2] vss vdd_periph in_srconn[2] in_srconn[3] in_shift in_latch d[16] d[17] d[18] d[19] d[20] d[21] d[22] d[23] we[2] SP6T3TimingIn_9SL
Xdwesr[3] vss vdd_periph in_srconn[3] in_srout in_shift in_latch d[24] d[25] d[26] d[27] d[28] d[29] d[30] d[31] we[3] SP6T3TimingIn_9SL
Xqsr[0] vss vdd_periph out_srconn[0] out_srconn[1] out_shift out_latch out_l2s q[0] q[1] q[2] q[3] q[4] q[5] q[6] q[7] SP6T3TimingOut_8SL
Xqsr[1] vss vdd_periph out_srconn[1] out_srconn[2] out_shift out_latch out_l2s q[8] q[9] q[10] q[11] q[12] q[13] q[14] q[15] SP6T3TimingOut_8SL
Xqsr[2] vss vdd_periph out_srconn[2] out_srconn[3] out_shift out_latch out_l2s q[16] q[17] q[18] q[19] q[20] q[21] q[22] q[23] SP6T3TimingOut_8SL
Xqsr[3] vss vdd_periph out_srconn[3] out_srout out_shift out_latch out_l2s q[24] q[25] q[26] q[27] q[28] q[29] q[30] q[31] SP6T3TimingOut_8SL
Xinsrin_antdio vdd_periph vss in_srin diode_w1
Xinshift_antdio vdd_periph vss in_shift diode_w1
Xinlatch_antdio vdd_periph vss in_latch diode_w1
Xfill[0] vdd_periph vss tie_w2
Xfill[1] vdd_periph vss tie_w2
Xoutlatch_antdio vdd_periph vss out_latch diode_w1
Xoutshift_antdio vdd_periph vss out_shift diode_w1
Xoutsrin_antdio vdd_periph vss out_srin diode_w1
Xoutl2s_antdio vdd_periph vss out_l2s diode_w1
Xclk_antdio vdd_periph vss clk diode_w1
Xfill[2] vdd_periph vss tie_w2
Xfill[3] vdd_periph vss tie_w2
.ends SP6T3Block_512x32_4we_C2B_R3B4B_Test

.subckt PadFrame_SP03 PAD0x0 PAD0x1 PAD0x2 PAD0x3 PAD0x4 PAD0x5 PAD0x6 PAD0x7 PAD0x8 PAD0x9 PAD1x0 PAD1x1 PAD1x2 PAD1x3 PAD1x4 PAD1x5 PAD1x6 PAD1x7 PAD1x8 PAD1x9
XPAD0x0 PAD0x0 BondPad
XPAD0x1 PAD0x1 BondPad
XPAD0x2 PAD0x2 BondPad
XPAD0x3 PAD0x3 BondPad
XPAD0x4 PAD0x4 BondPad
XPAD0x5 PAD0x5 BondPad
XPAD0x6 PAD0x6 BondPad
XPAD0x7 PAD0x7 BondPad
XPAD0x8 PAD0x8 BondPad
XPAD0x9 PAD0x9 BondPad
XPAD1x0 PAD1x0 BondPad
XPAD1x1 PAD1x1 BondPad
XPAD1x2 PAD1x2 BondPad
XPAD1x3 PAD1x3 BondPad
XPAD1x4 PAD1x4 BondPad
XPAD1x5 PAD1x5 BondPad
XPAD1x6 PAD1x6 BondPad
XPAD1x7 PAD1x7 BondPad
XPAD1x8 PAD1x8 BondPad
XPAD1x9 PAD1x9 BondPad
.ends PadFrame_SP03

.subckt SP03 vss vdd_periph vdd_block in_srout out_srout clk out_latch out_shift out_l2s out_srin in_shift in_srin in_latch
Xtestblock vss vdd_block vdd_periph clk in_shift in_latch in_srin in_srout out_shift out_latch out_l2s out_srin out_srout SP6T3Block_512x32_4we_C2B_R3B4B_Test
Xpadframe vdd_block vss clk out_shift out_srin in_srin in_latch noconn noconn noconn vdd_periph in_srout out_srout out_latch out_l2s in_shift noconn noconn noconn noconn PadFrame_SP03
.ends SP03

.subckt sp6t3_io clk in_srin in_latch in_shift out_srin out_latch out_shift out_l2s in_srout out_srout vdd_block
Xmem vss vdd_block_int vdd clk_int in_shift_int in_latch_int in_srin_int in_srout_int out_shift_int out_latch_int out_l2s_int out_srin_int out_srout_int SP6T3Block_512x32_4we_C2B_R3B4B_Test
Xclk_bp clk BondPad
Xclk_io clk clk_int sg13g2_IOPadIn
Xin_srin_bp in_srin BondPad
Xin_srin_io in_srin in_srin_int sg13g2_IOPadIn
Xin_latch_bp in_latch BondPad
Xin_latch_io in_latch in_latch_int sg13g2_IOPadIn
Xin_shift_bp in_shift BondPad
Xin_shift_io in_shift in_shift_int sg13g2_IOPadIn
Xout_srin_bp out_srin BondPad
Xout_srin_io out_srin out_srin_int sg13g2_IOPadIn
Xout_latch_bp out_latch BondPad
Xout_latch_io out_latch out_latch_int sg13g2_IOPadIn
Xout_shift_bp out_shift BondPad
Xout_shift_io out_shift out_shift_int sg13g2_IOPadIn
Xout_l2s_bp out_l2s BondPad
Xout_l2s_io out_l2s out_l2s_int sg13g2_IOPadIn
Xin_srout_bp in_srout BondPad
Xin_srout_io in_srout in_srout_int sg13g2_IOPadOut30mA
Xout_srout_bp out_srout BondPad
Xout_srout_io out_srout out_srout_int sg13g2_IOPadOut30mA
Xvdd_block_bp vdd_block BondPad
Xvdd_block_io vdd_block vdd_block_int sg13g2_IOPadAnalog
Xiofill0  sg13g2_Filler10000
Xiofill1  sg13g2_Filler10000
Xiofill2  sg13g2_Filler10000
Xiofill3  sg13g2_Filler10000
Xiofill4  sg13g2_Filler10000
Xiofill5  sg13g2_Filler10000
Xiofill6  sg13g2_Filler10000
Xiofill7  sg13g2_Filler10000
Xiofill8  sg13g2_Filler10000
Xiofill9  sg13g2_Filler10000
.ends sp6t3_io

.subckt Delay_buf_x1 vdd vss i q
Xstage0_nmos _i_n i vss vss sg13_lv_nmos l=2.5e-07 w=7.8e-07
Xstage0_pmos _i_n i vdd vdd sg13_lv_pmos l=2.5e-07 w=7.8e-07
Xnmos vss _i_n q vss sg13_lv_nmos l=2.5e-07 w=1.07e-06
Xpmos vdd _i_n q vdd sg13_lv_pmos l=2.5e-07 w=1.06e-06
.ends Delay_buf_x1

.subckt SP6T2ClockGen_4S11341D1R0C4WL vss vdd clk wl_en decodeclk columnclk precharge_n we_en
Xnonovl vss vdd clk firststage[0] firststage[1] firststage[2] firstpulse firststage[4] secondstage[0] secondstage[1] secondstage[2] secondpulse secondstage[4] SP6T2NonOvlClock_4S11341D1R
Xdecodeclkbuf vdd vss clk decodeclk buf_x1
Xcolumnclkbuf vdd vss clk columnclk buf_x1
Xprechargeinv vdd vss secondpulse precharge_n inv_x3
Xwlenbuf vdd vss delayed_wlen wl_en buf_x4
Xweenbuf vdd vss firstpulse we_en buf_x1
Xwlendelbuf[0] vdd vss firstpulse wlen_conn[0] Delay_buf_x1
Xwlendelbuf[1] vdd vss wlen_conn[0] wlen_conn[1] Delay_buf_x1
Xwlendelbuf[2] vdd vss wlen_conn[1] wlen_conn[2] Delay_buf_x1
Xwlendelbuf[3] vdd vss wlen_conn[2] delayed_wlen Delay_buf_x1
.ends SP6T2ClockGen_4S11341D1R0C4WL

.subckt SP6T2ClockGen_4S11341D1R1C2WL vss vdd clk delayed_clk wl_en decodeclk columnclk precharge_n we_en
Xnonovl vss vdd delayed_clk firststage[0] firststage[1] firststage[2] firstpulse firststage[4] secondstage[0] secondstage[1] secondstage[2] secondpulse secondstage[4] SP6T2NonOvlClock_4S11341D1R
Xdecodeclkbuf vdd vss delayed_clk decodeclk buf_x1
Xcolumnclkbuf vdd vss delayed_clk columnclk buf_x1
Xprechargeinv vdd vss secondpulse precharge_n inv_x3
Xwlenbuf vdd vss delayed_wlen wl_en buf_x4
Xweenbuf vdd vss firstpulse we_en buf_x1
Xclkbuf[0] vdd vss clk clk_conn[0] Delay_buf_x1
Xclkbuf[1] vdd vss clk_conn[0] delayed_clk Delay_buf_x1
Xwlendelbuf[0] vdd vss firstpulse wlen_conn[0] Delay_buf_x1
Xwlendelbuf[1] vdd vss wlen_conn[0] delayed_wlen Delay_buf_x1
.ends SP6T2ClockGen_4S11341D1R1C2WL

.subckt SP6T2ClockGen_4S11341D1R1C0WL vss vdd clk delayed_clk wl_en decodeclk columnclk precharge_n we_en
Xnonovl vss vdd delayed_clk firststage[0] firststage[1] firststage[2] firstpulse firststage[4] secondstage[0] secondstage[1] secondstage[2] secondpulse secondstage[4] SP6T2NonOvlClock_4S11341D1R
Xdecodeclkbuf vdd vss delayed_clk decodeclk buf_x1
Xcolumnclkbuf vdd vss delayed_clk columnclk buf_x1
Xprechargeinv vdd vss secondpulse precharge_n inv_x3
Xwlenbuf vdd vss firstpulse wl_en buf_x4
Xweenbuf vdd vss firstpulse we_en buf_x1
Xclkbuf[0] vdd vss clk clk_conn[0] Delay_buf_x1
Xclkbuf[1] vdd vss clk_conn[0] delayed_clk Delay_buf_x1
.ends SP6T2ClockGen_4S11341D1R1C0WL

.subckt SP6T2Block_512x32_4we_C2B_R3B4B_TMR2X clk a[0] a[1] a[2] a[3] a[4] a[5] a[6] a[7] a[8] vss vdd q[0] q[1] q[2] q[3] q[4] q[5] q[6] q[7] q[8] q[9] q[10] q[11] q[12] q[13] q[14] q[15] q[16] q[17] q[18] q[19] q[20] q[21] q[22] q[23] q[24] q[25] q[26] q[27] q[28] q[29] q[30] q[31] d[0] d[1] d[2] d[3] d[4] d[5] d[6] d[7] d[8] d[9] d[10] d[11] d[12] d[13] d[14] d[15] d[16] d[17] d[18] d[19] d[20] d[21] d[22] d[23] d[24] d[25] d[26] d[27] d[28] d[29] d[30] d[31] we[0] we[1] we[2] we[3]
Xcolumnblock vss vdd columnclk precharge_n we_en wl[0] wl[1] wl[2] wl[3] wl[4] wl[5] wl[6] wl[7] wl[8] wl[9] wl[10] wl[11] wl[12] wl[13] wl[14] wl[15] wl[16] wl[17] wl[18] wl[19] wl[20] wl[21] wl[22] wl[23] wl[24] wl[25] wl[26] wl[27] wl[28] wl[29] wl[30] wl[31] wl[32] wl[33] wl[34] wl[35] wl[36] wl[37] wl[38] wl[39] wl[40] wl[41] wl[42] wl[43] wl[44] wl[45] wl[46] wl[47] wl[48] wl[49] wl[50] wl[51] wl[52] wl[53] wl[54] wl[55] wl[56] wl[57] wl[58] wl[59] wl[60] wl[61] wl[62] wl[63] wl[64] wl[65] wl[66] wl[67] wl[68] wl[69] wl[70] wl[71] wl[72] wl[73] wl[74] wl[75] wl[76] wl[77] wl[78] wl[79] wl[80] wl[81] wl[82] wl[83] wl[84] wl[85] wl[86] wl[87] wl[88] wl[89] wl[90] wl[91] wl[92] wl[93] wl[94] wl[95] wl[96] wl[97] wl[98] wl[99] wl[100] wl[101] wl[102] wl[103] wl[104] wl[105] wl[106] wl[107] wl[108] wl[109] wl[110] wl[111] wl[112] wl[113] wl[114] wl[115] wl[116] wl[117] wl[118] wl[119] wl[120] wl[121] wl[122] wl[123] wl[124] wl[125] wl[126] wl[127] mux[0] mux[1] mux[2] mux[3] we[0] q[0] d[0] q[1] d[1] q[2] d[2] q[3] d[3] q[4] d[4] q[5] d[5] q[6] d[6] q[7] d[7] we[1] q[8] d[8] q[9] d[9] q[10] d[10] q[11] d[11] q[12] d[12] q[13] d[13] q[14] d[14] q[15] d[15] we[2] q[16] d[16] q[17] d[17] q[18] d[18] q[19] d[19] q[20] d[20] q[21] d[21] q[22] d[22] q[23] d[23] we[3] q[24] d[24] q[25] d[25] q[26] d[26] q[27] d[27] q[28] d[28] q[29] d[29] q[30] d[30] q[31] d[31] SP6T2ColumnBlock_COL128R_CP8B_CM4MN26L580W1R_PC26L100W_4WE
Xwldrivercol vss vdd wl[0] wl_n[0] wl[1] wl_n[1] wl[2] wl_n[2] wl[3] wl_n[3] wl[4] wl_n[4] wl[5] wl_n[5] wl[6] wl_n[6] wl[7] wl_n[7] wl[8] wl_n[8] wl[9] wl_n[9] wl[10] wl_n[10] wl[11] wl_n[11] wl[12] wl_n[12] wl[13] wl_n[13] wl[14] wl_n[14] wl[15] wl_n[15] wl[16] wl_n[16] wl[17] wl_n[17] wl[18] wl_n[18] wl[19] wl_n[19] wl[20] wl_n[20] wl[21] wl_n[21] wl[22] wl_n[22] wl[23] wl_n[23] wl[24] wl_n[24] wl[25] wl_n[25] wl[26] wl_n[26] wl[27] wl_n[27] wl[28] wl_n[28] wl[29] wl_n[29] wl[30] wl_n[30] wl[31] wl_n[31] wl[32] wl_n[32] wl[33] wl_n[33] wl[34] wl_n[34] wl[35] wl_n[35] wl[36] wl_n[36] wl[37] wl_n[37] wl[38] wl_n[38] wl[39] wl_n[39] wl[40] wl_n[40] wl[41] wl_n[41] wl[42] wl_n[42] wl[43] wl_n[43] wl[44] wl_n[44] wl[45] wl_n[45] wl[46] wl_n[46] wl[47] wl_n[47] wl[48] wl_n[48] wl[49] wl_n[49] wl[50] wl_n[50] wl[51] wl_n[51] wl[52] wl_n[52] wl[53] wl_n[53] wl[54] wl_n[54] wl[55] wl_n[55] wl[56] wl_n[56] wl[57] wl_n[57] wl[58] wl_n[58] wl[59] wl_n[59] wl[60] wl_n[60] wl[61] wl_n[61] wl[62] wl_n[62] wl[63] wl_n[63] wl[64] wl_n[64] wl[65] wl_n[65] wl[66] wl_n[66] wl[67] wl_n[67] wl[68] wl_n[68] wl[69] wl_n[69] wl[70] wl_n[70] wl[71] wl_n[71] wl[72] wl_n[72] wl[73] wl_n[73] wl[74] wl_n[74] wl[75] wl_n[75] wl[76] wl_n[76] wl[77] wl_n[77] wl[78] wl_n[78] wl[79] wl_n[79] wl[80] wl_n[80] wl[81] wl_n[81] wl[82] wl_n[82] wl[83] wl_n[83] wl[84] wl_n[84] wl[85] wl_n[85] wl[86] wl_n[86] wl[87] wl_n[87] wl[88] wl_n[88] wl[89] wl_n[89] wl[90] wl_n[90] wl[91] wl_n[91] wl[92] wl_n[92] wl[93] wl_n[93] wl[94] wl_n[94] wl[95] wl_n[95] wl[96] wl_n[96] wl[97] wl_n[97] wl[98] wl_n[98] wl[99] wl_n[99] wl[100] wl_n[100] wl[101] wl_n[101] wl[102] wl_n[102] wl[103] wl_n[103] wl[104] wl_n[104] wl[105] wl_n[105] wl[106] wl_n[106] wl[107] wl_n[107] wl[108] wl_n[108] wl[109] wl_n[109] wl[110] wl_n[110] wl[111] wl_n[111] wl[112] wl_n[112] wl[113] wl_n[113] wl[114] wl_n[114] wl[115] wl_n[115] wl[116] wl_n[116] wl[117] wl_n[117] wl[118] wl_n[118] wl[119] wl_n[119] wl[120] wl_n[120] wl[121] wl_n[121] wl[122] wl_n[122] wl[123] wl_n[123] wl[124] wl_n[124] wl[125] wl_n[125] wl[126] wl_n[126] wl[127] wl_n[127] SP6T2WLDriverCol_128RN26L400WP26L800W
Xclkgen1 vss vdd clk wl_en1 decodeclk1 columnclk precharge_n we_en SP6T2ClockGen_4S11341D1R0C4WL
Xclkgen2 vss vdd clk delayed_clk wl_en2 decodeclk2 noconn_columnclk2 noconn_precharge_n2 noconn_we_en2 SP6T2ClockGen_4S11341D1R1C2WL
Xclkgen3 vss vdd delayed_clk noconn_clk wl_en3 decodeclk3 noconn_columnclk3 noconn_precharge_n3 noconn_we_en3 SP6T2ClockGen_4S11341D1R1C0WL
Xrowperiph1 vss vdd a[0] a[1] a[2] a[3] a[4] a[5] a[6] a[7] a[8] wl_n[0] wl_n[1] wl_n[2] wl_n[3] wl_n[4] wl_n[5] wl_n[6] wl_n[7] wl_n[8] wl_n[9] wl_n[10] wl_n[11] wl_n[12] wl_n[13] wl_n[14] wl_n[15] wl_n[16] wl_n[17] wl_n[18] wl_n[19] wl_n[20] wl_n[21] wl_n[22] wl_n[23] wl_n[24] wl_n[25] wl_n[26] wl_n[27] wl_n[28] wl_n[29] wl_n[30] wl_n[31] wl_n[32] wl_n[33] wl_n[34] wl_n[35] wl_n[36] wl_n[37] wl_n[38] wl_n[39] wl_n[40] wl_n[41] wl_n[42] wl_n[43] wl_n[44] wl_n[45] wl_n[46] wl_n[47] wl_n[48] wl_n[49] wl_n[50] wl_n[51] wl_n[52] wl_n[53] wl_n[54] wl_n[55] wl_n[56] wl_n[57] wl_n[58] wl_n[59] wl_n[60] wl_n[61] wl_n[62] wl_n[63] wl_n[64] wl_n[65] wl_n[66] wl_n[67] wl_n[68] wl_n[69] wl_n[70] wl_n[71] wl_n[72] wl_n[73] wl_n[74] wl_n[75] wl_n[76] wl_n[77] wl_n[78] wl_n[79] wl_n[80] wl_n[81] wl_n[82] wl_n[83] wl_n[84] wl_n[85] wl_n[86] wl_n[87] wl_n[88] wl_n[89] wl_n[90] wl_n[91] wl_n[92] wl_n[93] wl_n[94] wl_n[95] wl_n[96] wl_n[97] wl_n[98] wl_n[99] wl_n[100] wl_n[101] wl_n[102] wl_n[103] wl_n[104] wl_n[105] wl_n[106] wl_n[107] wl_n[108] wl_n[109] wl_n[110] wl_n[111] wl_n[112] wl_n[113] wl_n[114] wl_n[115] wl_n[116] wl_n[117] wl_n[118] wl_n[119] wl_n[120] wl_n[121] wl_n[122] wl_n[123] wl_n[124] wl_n[125] wl_n[126] wl_n[127] decodeclk1 wl_en1 mux[0] mux[1] mux[2] mux[3] SP6T2RowPeriph_PD3B4B_LD2B2R
Xrowperiph2 vss vdd a[0] a[1] a[2] a[3] a[4] a[5] a[6] a[7] a[8] wl_n[0] wl_n[1] wl_n[2] wl_n[3] wl_n[4] wl_n[5] wl_n[6] wl_n[7] wl_n[8] wl_n[9] wl_n[10] wl_n[11] wl_n[12] wl_n[13] wl_n[14] wl_n[15] wl_n[16] wl_n[17] wl_n[18] wl_n[19] wl_n[20] wl_n[21] wl_n[22] wl_n[23] wl_n[24] wl_n[25] wl_n[26] wl_n[27] wl_n[28] wl_n[29] wl_n[30] wl_n[31] wl_n[32] wl_n[33] wl_n[34] wl_n[35] wl_n[36] wl_n[37] wl_n[38] wl_n[39] wl_n[40] wl_n[41] wl_n[42] wl_n[43] wl_n[44] wl_n[45] wl_n[46] wl_n[47] wl_n[48] wl_n[49] wl_n[50] wl_n[51] wl_n[52] wl_n[53] wl_n[54] wl_n[55] wl_n[56] wl_n[57] wl_n[58] wl_n[59] wl_n[60] wl_n[61] wl_n[62] wl_n[63] wl_n[64] wl_n[65] wl_n[66] wl_n[67] wl_n[68] wl_n[69] wl_n[70] wl_n[71] wl_n[72] wl_n[73] wl_n[74] wl_n[75] wl_n[76] wl_n[77] wl_n[78] wl_n[79] wl_n[80] wl_n[81] wl_n[82] wl_n[83] wl_n[84] wl_n[85] wl_n[86] wl_n[87] wl_n[88] wl_n[89] wl_n[90] wl_n[91] wl_n[92] wl_n[93] wl_n[94] wl_n[95] wl_n[96] wl_n[97] wl_n[98] wl_n[99] wl_n[100] wl_n[101] wl_n[102] wl_n[103] wl_n[104] wl_n[105] wl_n[106] wl_n[107] wl_n[108] wl_n[109] wl_n[110] wl_n[111] wl_n[112] wl_n[113] wl_n[114] wl_n[115] wl_n[116] wl_n[117] wl_n[118] wl_n[119] wl_n[120] wl_n[121] wl_n[122] wl_n[123] wl_n[124] wl_n[125] wl_n[126] wl_n[127] decodeclk2 wl_en2 mux[0] mux[1] mux[2] mux[3] SP6T2RowPeriph_PD3B4B_LD2B2R
Xrowperiph3 vss vdd a[0] a[1] a[2] a[3] a[4] a[5] a[6] a[7] a[8] wl_n[0] wl_n[1] wl_n[2] wl_n[3] wl_n[4] wl_n[5] wl_n[6] wl_n[7] wl_n[8] wl_n[9] wl_n[10] wl_n[11] wl_n[12] wl_n[13] wl_n[14] wl_n[15] wl_n[16] wl_n[17] wl_n[18] wl_n[19] wl_n[20] wl_n[21] wl_n[22] wl_n[23] wl_n[24] wl_n[25] wl_n[26] wl_n[27] wl_n[28] wl_n[29] wl_n[30] wl_n[31] wl_n[32] wl_n[33] wl_n[34] wl_n[35] wl_n[36] wl_n[37] wl_n[38] wl_n[39] wl_n[40] wl_n[41] wl_n[42] wl_n[43] wl_n[44] wl_n[45] wl_n[46] wl_n[47] wl_n[48] wl_n[49] wl_n[50] wl_n[51] wl_n[52] wl_n[53] wl_n[54] wl_n[55] wl_n[56] wl_n[57] wl_n[58] wl_n[59] wl_n[60] wl_n[61] wl_n[62] wl_n[63] wl_n[64] wl_n[65] wl_n[66] wl_n[67] wl_n[68] wl_n[69] wl_n[70] wl_n[71] wl_n[72] wl_n[73] wl_n[74] wl_n[75] wl_n[76] wl_n[77] wl_n[78] wl_n[79] wl_n[80] wl_n[81] wl_n[82] wl_n[83] wl_n[84] wl_n[85] wl_n[86] wl_n[87] wl_n[88] wl_n[89] wl_n[90] wl_n[91] wl_n[92] wl_n[93] wl_n[94] wl_n[95] wl_n[96] wl_n[97] wl_n[98] wl_n[99] wl_n[100] wl_n[101] wl_n[102] wl_n[103] wl_n[104] wl_n[105] wl_n[106] wl_n[107] wl_n[108] wl_n[109] wl_n[110] wl_n[111] wl_n[112] wl_n[113] wl_n[114] wl_n[115] wl_n[116] wl_n[117] wl_n[118] wl_n[119] wl_n[120] wl_n[121] wl_n[122] wl_n[123] wl_n[124] wl_n[125] wl_n[126] wl_n[127] decodeclk3 wl_en3 mux[0] mux[1] mux[2] mux[3] SP6T2RowPeriph_PD3B4B_LD2B2R
.ends SP6T2Block_512x32_4we_C2B_R3B4B_TMR2X

.subckt SP6T2Block_512x32_4we_C2B_R3B4B_TMR2X_Test vss vdd_block vdd_periph clk in_shift in_latch in_srin in_srout out_shift out_latch out_l2s out_srin out_srout
Xblock clk a[0] a[1] a[2] a[3] a[4] a[5] a[6] a[7] a[8] vss vdd_block q[0] q[1] q[2] q[3] q[4] q[5] q[6] q[7] q[8] q[9] q[10] q[11] q[12] q[13] q[14] q[15] q[16] q[17] q[18] q[19] q[20] q[21] q[22] q[23] q[24] q[25] q[26] q[27] q[28] q[29] q[30] q[31] d[0] d[1] d[2] d[3] d[4] d[5] d[6] d[7] d[8] d[9] d[10] d[11] d[12] d[13] d[14] d[15] d[16] d[17] d[18] d[19] d[20] d[21] d[22] d[23] d[24] d[25] d[26] d[27] d[28] d[29] d[30] d[31] we[0] we[1] we[2] we[3] SP6T2Block_512x32_4we_C2B_R3B4B_TMR2X
Xasr vss vdd_periph in_srin in_srconn[0] in_shift in_latch a[8] a[7] a[6] a[5] a[4] a[3] a[2] a[1] a[0] SP6T2TimingIn_9SF
Xclksr vss vdd_periph out_srin out_srconn[0] out_shift clk out_l2s in_latch out_latch SP6T2TimingOut_2SL
Xdwesr[0] vss vdd_periph in_srconn[0] in_srconn[1] in_shift in_latch d[0] d[1] d[2] d[3] d[4] d[5] d[6] d[7] we[0] SP6T2TimingIn_9SL
Xdwesr[1] vss vdd_periph in_srconn[1] in_srconn[2] in_shift in_latch d[8] d[9] d[10] d[11] d[12] d[13] d[14] d[15] we[1] SP6T2TimingIn_9SL
Xdwesr[2] vss vdd_periph in_srconn[2] in_srconn[3] in_shift in_latch d[16] d[17] d[18] d[19] d[20] d[21] d[22] d[23] we[2] SP6T2TimingIn_9SL
Xdwesr[3] vss vdd_periph in_srconn[3] in_srout in_shift in_latch d[24] d[25] d[26] d[27] d[28] d[29] d[30] d[31] we[3] SP6T2TimingIn_9SL
Xqsr[0] vss vdd_periph out_srconn[0] out_srconn[1] out_shift out_latch out_l2s q[0] q[1] q[2] q[3] q[4] q[5] q[6] q[7] SP6T2TimingOut_8SL
Xqsr[1] vss vdd_periph out_srconn[1] out_srconn[2] out_shift out_latch out_l2s q[8] q[9] q[10] q[11] q[12] q[13] q[14] q[15] SP6T2TimingOut_8SL
Xqsr[2] vss vdd_periph out_srconn[2] out_srconn[3] out_shift out_latch out_l2s q[16] q[17] q[18] q[19] q[20] q[21] q[22] q[23] SP6T2TimingOut_8SL
Xqsr[3] vss vdd_periph out_srconn[3] out_srout out_shift out_latch out_l2s q[24] q[25] q[26] q[27] q[28] q[29] q[30] q[31] SP6T2TimingOut_8SL
Xinsrin_antdio vdd_periph vss in_srin diode_w1
Xinshift_antdio vdd_periph vss in_shift diode_w1
Xinlatch_antdio vdd_periph vss in_latch diode_w1
Xfill[0] vdd_periph vss tie_w2
Xfill[1] vdd_periph vss tie_w2
Xoutlatch_antdio vdd_periph vss out_latch diode_w1
Xoutshift_antdio vdd_periph vss out_shift diode_w1
Xoutsrin_antdio vdd_periph vss out_srin diode_w1
Xoutl2s_antdio vdd_periph vss out_l2s diode_w1
Xclk_antdio vdd_periph vss clk diode_w1
Xfill[2] vdd_periph vss tie_w2
Xfill[3] vdd_periph vss tie_w2
.ends SP6T2Block_512x32_4we_C2B_R3B4B_TMR2X_Test

.subckt PadFrame_TMRR PAD0x0 PAD0x1 PAD0x2 PAD0x3 PAD0x4 PAD0x5 PAD0x6 PAD0x7 PAD0x8 PAD0x9 PAD1x0 PAD1x1 PAD1x2 PAD1x3 PAD1x4 PAD1x5 PAD1x6 PAD1x7 PAD1x8 PAD1x9
XPAD0x0 PAD0x0 BondPad
XPAD0x1 PAD0x1 BondPad
XPAD0x2 PAD0x2 BondPad
XPAD0x3 PAD0x3 BondPad
XPAD0x4 PAD0x4 BondPad
XPAD0x5 PAD0x5 BondPad
XPAD0x6 PAD0x6 BondPad
XPAD0x7 PAD0x7 BondPad
XPAD0x8 PAD0x8 BondPad
XPAD0x9 PAD0x9 BondPad
XPAD1x0 PAD1x0 BondPad
XPAD1x1 PAD1x1 BondPad
XPAD1x2 PAD1x2 BondPad
XPAD1x3 PAD1x3 BondPad
XPAD1x4 PAD1x4 BondPad
XPAD1x5 PAD1x5 BondPad
XPAD1x6 PAD1x6 BondPad
XPAD1x7 PAD1x7 BondPad
XPAD1x8 PAD1x8 BondPad
XPAD1x9 PAD1x9 BondPad
.ends PadFrame_TMRR

.subckt TMRR vss vdd_periph vdd_block in_srout out_srout clk out_latch out_shift out_l2s out_srin in_shift in_srin in_latch
Xtestblock vss vdd_block vdd_periph clk in_shift in_latch in_srin in_srout out_shift out_latch out_l2s out_srin out_srout SP6T2Block_512x32_4we_C2B_R3B4B_TMR2X_Test
Xpadframe vdd_block vss clk out_shift out_srin in_srin in_latch noconn noconn noconn vdd_periph in_srout out_srout out_latch out_l2s in_shift noconn noconn noconn noconn PadFrame_TMRR
.ends TMRR

.subckt sp6ttmr_io clk in_srin in_latch in_shift out_srin out_latch out_shift out_l2s in_srout out_srout vdd_block
Xmem vss vdd_block_int vdd clk_int in_shift_int in_latch_int in_srin_int in_srout_int out_shift_int out_latch_int out_l2s_int out_srin_int out_srout_int SP6T2Block_512x32_4we_C2B_R3B4B_TMR2X_Test
Xclk_bp clk BondPad
Xclk_io clk clk_int sg13g2_IOPadIn
Xin_srin_bp in_srin BondPad
Xin_srin_io in_srin in_srin_int sg13g2_IOPadIn
Xin_latch_bp in_latch BondPad
Xin_latch_io in_latch in_latch_int sg13g2_IOPadIn
Xin_shift_bp in_shift BondPad
Xin_shift_io in_shift in_shift_int sg13g2_IOPadIn
Xout_srin_bp out_srin BondPad
Xout_srin_io out_srin out_srin_int sg13g2_IOPadIn
Xout_latch_bp out_latch BondPad
Xout_latch_io out_latch out_latch_int sg13g2_IOPadIn
Xout_shift_bp out_shift BondPad
Xout_shift_io out_shift out_shift_int sg13g2_IOPadIn
Xout_l2s_bp out_l2s BondPad
Xout_l2s_io out_l2s out_l2s_int sg13g2_IOPadIn
Xin_srout_bp in_srout BondPad
Xin_srout_io in_srout in_srout_int sg13g2_IOPadOut30mA
Xout_srout_bp out_srout BondPad
Xout_srout_io out_srout out_srout_int sg13g2_IOPadOut30mA
Xvdd_block_bp vdd_block BondPad
Xvdd_block_io vdd_block vdd_block_int sg13g2_IOPadAnalog
Xiofill0  sg13g2_Filler10000
Xiofill1  sg13g2_Filler10000
Xiofill2  sg13g2_Filler10000
Xiofill3  sg13g2_Filler10000
Xiofill4  sg13g2_Filler10000
Xiofill5  sg13g2_Filler10000
Xiofill6  sg13g2_Filler10000
Xiofill7  sg13g2_Filler10000
Xiofill8  sg13g2_Filler10000
Xiofill9  sg13g2_Filler10000
.ends sp6ttmr_io

.subckt SPDICECell vss substrate vdd nwell wl bl bl_n
Xpu[0] vdd bit[0] bit_n[0] nwell sg13_lv_pmos l=1.3e-07 w=3.4e-07
Xpu[1] vdd bit_n[0] bit[1] nwell sg13_lv_pmos l=1.3e-07 w=3.4e-07
Xpu[2] vdd bit[1] bit_n[1] nwell sg13_lv_pmos l=1.3e-07 w=3.4e-07
Xpu[3] vdd bit_n[1] bit[0] nwell sg13_lv_pmos l=1.3e-07 w=3.4e-07
Xpd[0] bit_n[1] bit[0] vss substrate sg13_lv_nmos l=1.3e-07 w=3.4e-07
Xpd[1] bit[0] bit_n[0] vss substrate sg13_lv_nmos l=1.3e-07 w=3.4e-07
Xpd[2] bit_n[0] bit[1] vss substrate sg13_lv_nmos l=1.3e-07 w=3.4e-07
Xpd[3] bit[1] bit_n[1] vss substrate sg13_lv_nmos l=1.3e-07 w=3.4e-07
Xpg[0] bit_n[1] wl bl_n substrate sg13_lv_nmos l=1.3e-07 w=2e-07
Xpg[1] bit[0] wl bl substrate sg13_lv_nmos l=1.3e-07 w=2e-07
Xpg[2] bit_n[0] wl bl_n substrate sg13_lv_nmos l=1.3e-07 w=2e-07
Xpg[3] bit[1] wl bl substrate sg13_lv_nmos l=1.3e-07 w=2e-07
.ends SPDICECell

.subckt SPDICEArray_2X1 vss substrate vdd nwell wl[0] wl[1] bl[0] bl_n[0]
Xinst0x0 vss substrate vdd nwell wl[0] bl[0] bl_n[0] SPDICECell
Xinst1x0 vss substrate vdd nwell wl[1] bl[0] bl_n[0] SPDICECell
.ends SPDICEArray_2X1

.subckt SPDICEArray_2X2 vss substrate vdd nwell wl[0] wl[1] bl[0] bl_n[0] bl[1] bl_n[1]
Xinst0x0 vss substrate vdd nwell wl[0] wl[1] bl[0] bl_n[0] SPDICEArray_2X1
Xinst0x1 vss substrate vdd nwell wl[0] wl[1] bl[1] bl_n[1] SPDICEArray_2X1
.ends SPDICEArray_2X2

.subckt SPDICEArray_4X2 vss substrate vdd nwell wl[0] wl[1] wl[2] wl[3] bl[0] bl_n[0] bl[1] bl_n[1]
Xinst0x0 vss substrate vdd nwell wl[0] wl[1] bl[0] bl_n[0] bl[1] bl_n[1] SPDICEArray_2X2
Xinst1x0 vss substrate vdd nwell wl[2] wl[3] bl[0] bl_n[0] bl[1] bl_n[1] SPDICEArray_2X2
.ends SPDICEArray_4X2

.subckt SPDICEArray_4X4 vss substrate vdd nwell wl[0] wl[1] wl[2] wl[3] bl[0] bl_n[0] bl[1] bl_n[1] bl[2] bl_n[2] bl[3] bl_n[3]
Xinst0x0 vss substrate vdd nwell wl[0] wl[1] wl[2] wl[3] bl[0] bl_n[0] bl[1] bl_n[1] SPDICEArray_4X2
Xinst0x1 vss substrate vdd nwell wl[0] wl[1] wl[2] wl[3] bl[2] bl_n[2] bl[3] bl_n[3] SPDICEArray_4X2
.ends SPDICEArray_4X4

.subckt SPDICEArray_8X4 vss substrate vdd nwell wl[0] wl[1] wl[2] wl[3] wl[4] wl[5] wl[6] wl[7] bl[0] bl_n[0] bl[1] bl_n[1] bl[2] bl_n[2] bl[3] bl_n[3]
Xinst0x0 vss substrate vdd nwell wl[0] wl[1] wl[2] wl[3] bl[0] bl_n[0] bl[1] bl_n[1] bl[2] bl_n[2] bl[3] bl_n[3] SPDICEArray_4X4
Xinst1x0 vss substrate vdd nwell wl[4] wl[5] wl[6] wl[7] bl[0] bl_n[0] bl[1] bl_n[1] bl[2] bl_n[2] bl[3] bl_n[3] SPDICEArray_4X4
.ends SPDICEArray_8X4

.subckt SPDICEArray_8X8 vss substrate vdd nwell wl[0] wl[1] wl[2] wl[3] wl[4] wl[5] wl[6] wl[7] bl[0] bl_n[0] bl[1] bl_n[1] bl[2] bl_n[2] bl[3] bl_n[3] bl[4] bl_n[4] bl[5] bl_n[5] bl[6] bl_n[6] bl[7] bl_n[7]
Xinst0x0 vss substrate vdd nwell wl[0] wl[1] wl[2] wl[3] wl[4] wl[5] wl[6] wl[7] bl[0] bl_n[0] bl[1] bl_n[1] bl[2] bl_n[2] bl[3] bl_n[3] SPDICEArray_8X4
Xinst0x1 vss substrate vdd nwell wl[0] wl[1] wl[2] wl[3] wl[4] wl[5] wl[6] wl[7] bl[4] bl_n[4] bl[5] bl_n[5] bl[6] bl_n[6] bl[7] bl_n[7] SPDICEArray_8X4
.ends SPDICEArray_8X8

.subckt SPDICEArray_16X8 vss substrate vdd nwell wl[0] wl[1] wl[2] wl[3] wl[4] wl[5] wl[6] wl[7] wl[8] wl[9] wl[10] wl[11] wl[12] wl[13] wl[14] wl[15] bl[0] bl_n[0] bl[1] bl_n[1] bl[2] bl_n[2] bl[3] bl_n[3] bl[4] bl_n[4] bl[5] bl_n[5] bl[6] bl_n[6] bl[7] bl_n[7]
Xinst0x0 vss substrate vdd nwell wl[0] wl[1] wl[2] wl[3] wl[4] wl[5] wl[6] wl[7] bl[0] bl_n[0] bl[1] bl_n[1] bl[2] bl_n[2] bl[3] bl_n[3] bl[4] bl_n[4] bl[5] bl_n[5] bl[6] bl_n[6] bl[7] bl_n[7] SPDICEArray_8X8
Xinst1x0 vss substrate vdd nwell wl[8] wl[9] wl[10] wl[11] wl[12] wl[13] wl[14] wl[15] bl[0] bl_n[0] bl[1] bl_n[1] bl[2] bl_n[2] bl[3] bl_n[3] bl[4] bl_n[4] bl[5] bl_n[5] bl[6] bl_n[6] bl[7] bl_n[7] SPDICEArray_8X8
.ends SPDICEArray_16X8

.subckt SPDICEArray_32X8 vss substrate vdd nwell wl[0] wl[1] wl[2] wl[3] wl[4] wl[5] wl[6] wl[7] wl[8] wl[9] wl[10] wl[11] wl[12] wl[13] wl[14] wl[15] wl[16] wl[17] wl[18] wl[19] wl[20] wl[21] wl[22] wl[23] wl[24] wl[25] wl[26] wl[27] wl[28] wl[29] wl[30] wl[31] bl[0] bl_n[0] bl[1] bl_n[1] bl[2] bl_n[2] bl[3] bl_n[3] bl[4] bl_n[4] bl[5] bl_n[5] bl[6] bl_n[6] bl[7] bl_n[7]
Xinst0x0 vss substrate vdd nwell wl[0] wl[1] wl[2] wl[3] wl[4] wl[5] wl[6] wl[7] wl[8] wl[9] wl[10] wl[11] wl[12] wl[13] wl[14] wl[15] bl[0] bl_n[0] bl[1] bl_n[1] bl[2] bl_n[2] bl[3] bl_n[3] bl[4] bl_n[4] bl[5] bl_n[5] bl[6] bl_n[6] bl[7] bl_n[7] SPDICEArray_16X8
Xinst1x0 vss substrate vdd nwell wl[16] wl[17] wl[18] wl[19] wl[20] wl[21] wl[22] wl[23] wl[24] wl[25] wl[26] wl[27] wl[28] wl[29] wl[30] wl[31] bl[0] bl_n[0] bl[1] bl_n[1] bl[2] bl_n[2] bl[3] bl_n[3] bl[4] bl_n[4] bl[5] bl_n[5] bl[6] bl_n[6] bl[7] bl_n[7] SPDICEArray_16X8
.ends SPDICEArray_32X8

.subckt SPDICEArray_64X8 vss substrate vdd nwell wl[0] wl[1] wl[2] wl[3] wl[4] wl[5] wl[6] wl[7] wl[8] wl[9] wl[10] wl[11] wl[12] wl[13] wl[14] wl[15] wl[16] wl[17] wl[18] wl[19] wl[20] wl[21] wl[22] wl[23] wl[24] wl[25] wl[26] wl[27] wl[28] wl[29] wl[30] wl[31] wl[32] wl[33] wl[34] wl[35] wl[36] wl[37] wl[38] wl[39] wl[40] wl[41] wl[42] wl[43] wl[44] wl[45] wl[46] wl[47] wl[48] wl[49] wl[50] wl[51] wl[52] wl[53] wl[54] wl[55] wl[56] wl[57] wl[58] wl[59] wl[60] wl[61] wl[62] wl[63] bl[0] bl_n[0] bl[1] bl_n[1] bl[2] bl_n[2] bl[3] bl_n[3] bl[4] bl_n[4] bl[5] bl_n[5] bl[6] bl_n[6] bl[7] bl_n[7]
Xinst0x0 vss substrate vdd nwell wl[0] wl[1] wl[2] wl[3] wl[4] wl[5] wl[6] wl[7] wl[8] wl[9] wl[10] wl[11] wl[12] wl[13] wl[14] wl[15] wl[16] wl[17] wl[18] wl[19] wl[20] wl[21] wl[22] wl[23] wl[24] wl[25] wl[26] wl[27] wl[28] wl[29] wl[30] wl[31] bl[0] bl_n[0] bl[1] bl_n[1] bl[2] bl_n[2] bl[3] bl_n[3] bl[4] bl_n[4] bl[5] bl_n[5] bl[6] bl_n[6] bl[7] bl_n[7] SPDICEArray_32X8
Xinst1x0 vss substrate vdd nwell wl[32] wl[33] wl[34] wl[35] wl[36] wl[37] wl[38] wl[39] wl[40] wl[41] wl[42] wl[43] wl[44] wl[45] wl[46] wl[47] wl[48] wl[49] wl[50] wl[51] wl[52] wl[53] wl[54] wl[55] wl[56] wl[57] wl[58] wl[59] wl[60] wl[61] wl[62] wl[63] bl[0] bl_n[0] bl[1] bl_n[1] bl[2] bl_n[2] bl[3] bl_n[3] bl[4] bl_n[4] bl[5] bl_n[5] bl[6] bl_n[6] bl[7] bl_n[7] SPDICEArray_32X8
.ends SPDICEArray_64X8

.subckt SPDICEArray_128X8 vss substrate vdd nwell wl[0] wl[1] wl[2] wl[3] wl[4] wl[5] wl[6] wl[7] wl[8] wl[9] wl[10] wl[11] wl[12] wl[13] wl[14] wl[15] wl[16] wl[17] wl[18] wl[19] wl[20] wl[21] wl[22] wl[23] wl[24] wl[25] wl[26] wl[27] wl[28] wl[29] wl[30] wl[31] wl[32] wl[33] wl[34] wl[35] wl[36] wl[37] wl[38] wl[39] wl[40] wl[41] wl[42] wl[43] wl[44] wl[45] wl[46] wl[47] wl[48] wl[49] wl[50] wl[51] wl[52] wl[53] wl[54] wl[55] wl[56] wl[57] wl[58] wl[59] wl[60] wl[61] wl[62] wl[63] wl[64] wl[65] wl[66] wl[67] wl[68] wl[69] wl[70] wl[71] wl[72] wl[73] wl[74] wl[75] wl[76] wl[77] wl[78] wl[79] wl[80] wl[81] wl[82] wl[83] wl[84] wl[85] wl[86] wl[87] wl[88] wl[89] wl[90] wl[91] wl[92] wl[93] wl[94] wl[95] wl[96] wl[97] wl[98] wl[99] wl[100] wl[101] wl[102] wl[103] wl[104] wl[105] wl[106] wl[107] wl[108] wl[109] wl[110] wl[111] wl[112] wl[113] wl[114] wl[115] wl[116] wl[117] wl[118] wl[119] wl[120] wl[121] wl[122] wl[123] wl[124] wl[125] wl[126] wl[127] bl[0] bl_n[0] bl[1] bl_n[1] bl[2] bl_n[2] bl[3] bl_n[3] bl[4] bl_n[4] bl[5] bl_n[5] bl[6] bl_n[6] bl[7] bl_n[7]
Xinst0x0 vss substrate vdd nwell wl[0] wl[1] wl[2] wl[3] wl[4] wl[5] wl[6] wl[7] wl[8] wl[9] wl[10] wl[11] wl[12] wl[13] wl[14] wl[15] wl[16] wl[17] wl[18] wl[19] wl[20] wl[21] wl[22] wl[23] wl[24] wl[25] wl[26] wl[27] wl[28] wl[29] wl[30] wl[31] wl[32] wl[33] wl[34] wl[35] wl[36] wl[37] wl[38] wl[39] wl[40] wl[41] wl[42] wl[43] wl[44] wl[45] wl[46] wl[47] wl[48] wl[49] wl[50] wl[51] wl[52] wl[53] wl[54] wl[55] wl[56] wl[57] wl[58] wl[59] wl[60] wl[61] wl[62] wl[63] bl[0] bl_n[0] bl[1] bl_n[1] bl[2] bl_n[2] bl[3] bl_n[3] bl[4] bl_n[4] bl[5] bl_n[5] bl[6] bl_n[6] bl[7] bl_n[7] SPDICEArray_64X8
Xinst1x0 vss substrate vdd nwell wl[64] wl[65] wl[66] wl[67] wl[68] wl[69] wl[70] wl[71] wl[72] wl[73] wl[74] wl[75] wl[76] wl[77] wl[78] wl[79] wl[80] wl[81] wl[82] wl[83] wl[84] wl[85] wl[86] wl[87] wl[88] wl[89] wl[90] wl[91] wl[92] wl[93] wl[94] wl[95] wl[96] wl[97] wl[98] wl[99] wl[100] wl[101] wl[102] wl[103] wl[104] wl[105] wl[106] wl[107] wl[108] wl[109] wl[110] wl[111] wl[112] wl[113] wl[114] wl[115] wl[116] wl[117] wl[118] wl[119] wl[120] wl[121] wl[122] wl[123] wl[124] wl[125] wl[126] wl[127] bl[0] bl_n[0] bl[1] bl_n[1] bl[2] bl_n[2] bl[3] bl_n[3] bl[4] bl_n[4] bl[5] bl_n[5] bl[6] bl_n[6] bl[7] bl_n[7] SPDICEArray_64X8
.ends SPDICEArray_128X8

.subckt SPDICEBulkConn vss vdd wl
.ends SPDICEBulkConn

.subckt SPDICEBulkConnCol_2R vss vdd wl[0] wl[1]
Xinst0 vss vdd wl[0] SPDICEBulkConn
Xinst1 vss vdd wl[1] SPDICEBulkConn
.ends SPDICEBulkConnCol_2R

.subckt SPDICEBulkConnCol_4R vss vdd wl[0] wl[2] wl[1] wl[3]
Xinst0 vss vdd wl[0] wl[1] SPDICEBulkConnCol_2R
Xinst1 vss vdd wl[2] wl[3] SPDICEBulkConnCol_2R
.ends SPDICEBulkConnCol_4R

.subckt SPDICEBulkConnCol_8R vss vdd wl[0] wl[4] wl[1] wl[5] wl[2] wl[6] wl[3] wl[7]
Xinst0 vss vdd wl[0] wl[2] wl[1] wl[3] SPDICEBulkConnCol_4R
Xinst1 vss vdd wl[4] wl[6] wl[5] wl[7] SPDICEBulkConnCol_4R
.ends SPDICEBulkConnCol_8R

.subckt SPDICEBulkConnCol_16R vss vdd wl[0] wl[8] wl[1] wl[9] wl[2] wl[10] wl[3] wl[11] wl[4] wl[12] wl[5] wl[13] wl[6] wl[14] wl[7] wl[15]
Xinst0 vss vdd wl[0] wl[4] wl[1] wl[5] wl[2] wl[6] wl[3] wl[7] SPDICEBulkConnCol_8R
Xinst1 vss vdd wl[8] wl[12] wl[9] wl[13] wl[10] wl[14] wl[11] wl[15] SPDICEBulkConnCol_8R
.ends SPDICEBulkConnCol_16R

.subckt SPDICEBulkConnCol_32R vss vdd wl[0] wl[16] wl[1] wl[17] wl[2] wl[18] wl[3] wl[19] wl[4] wl[20] wl[5] wl[21] wl[6] wl[22] wl[7] wl[23] wl[8] wl[24] wl[9] wl[25] wl[10] wl[26] wl[11] wl[27] wl[12] wl[28] wl[13] wl[29] wl[14] wl[30] wl[15] wl[31]
Xinst0 vss vdd wl[0] wl[8] wl[1] wl[9] wl[2] wl[10] wl[3] wl[11] wl[4] wl[12] wl[5] wl[13] wl[6] wl[14] wl[7] wl[15] SPDICEBulkConnCol_16R
Xinst1 vss vdd wl[16] wl[24] wl[17] wl[25] wl[18] wl[26] wl[19] wl[27] wl[20] wl[28] wl[21] wl[29] wl[22] wl[30] wl[23] wl[31] SPDICEBulkConnCol_16R
.ends SPDICEBulkConnCol_32R

.subckt SPDICEBulkConnCol_64R vss vdd wl[0] wl[32] wl[1] wl[33] wl[2] wl[34] wl[3] wl[35] wl[4] wl[36] wl[5] wl[37] wl[6] wl[38] wl[7] wl[39] wl[8] wl[40] wl[9] wl[41] wl[10] wl[42] wl[11] wl[43] wl[12] wl[44] wl[13] wl[45] wl[14] wl[46] wl[15] wl[47] wl[16] wl[48] wl[17] wl[49] wl[18] wl[50] wl[19] wl[51] wl[20] wl[52] wl[21] wl[53] wl[22] wl[54] wl[23] wl[55] wl[24] wl[56] wl[25] wl[57] wl[26] wl[58] wl[27] wl[59] wl[28] wl[60] wl[29] wl[61] wl[30] wl[62] wl[31] wl[63]
Xinst0 vss vdd wl[0] wl[16] wl[1] wl[17] wl[2] wl[18] wl[3] wl[19] wl[4] wl[20] wl[5] wl[21] wl[6] wl[22] wl[7] wl[23] wl[8] wl[24] wl[9] wl[25] wl[10] wl[26] wl[11] wl[27] wl[12] wl[28] wl[13] wl[29] wl[14] wl[30] wl[15] wl[31] SPDICEBulkConnCol_32R
Xinst1 vss vdd wl[32] wl[48] wl[33] wl[49] wl[34] wl[50] wl[35] wl[51] wl[36] wl[52] wl[37] wl[53] wl[38] wl[54] wl[39] wl[55] wl[40] wl[56] wl[41] wl[57] wl[42] wl[58] wl[43] wl[59] wl[44] wl[60] wl[45] wl[61] wl[46] wl[62] wl[47] wl[63] SPDICEBulkConnCol_32R
.ends SPDICEBulkConnCol_64R

.subckt SPDICEBulkConnCol_128R vss vdd wl[0] wl[64] wl[1] wl[65] wl[2] wl[66] wl[3] wl[67] wl[4] wl[68] wl[5] wl[69] wl[6] wl[70] wl[7] wl[71] wl[8] wl[72] wl[9] wl[73] wl[10] wl[74] wl[11] wl[75] wl[12] wl[76] wl[13] wl[77] wl[14] wl[78] wl[15] wl[79] wl[16] wl[80] wl[17] wl[81] wl[18] wl[82] wl[19] wl[83] wl[20] wl[84] wl[21] wl[85] wl[22] wl[86] wl[23] wl[87] wl[24] wl[88] wl[25] wl[89] wl[26] wl[90] wl[27] wl[91] wl[28] wl[92] wl[29] wl[93] wl[30] wl[94] wl[31] wl[95] wl[32] wl[96] wl[33] wl[97] wl[34] wl[98] wl[35] wl[99] wl[36] wl[100] wl[37] wl[101] wl[38] wl[102] wl[39] wl[103] wl[40] wl[104] wl[41] wl[105] wl[42] wl[106] wl[43] wl[107] wl[44] wl[108] wl[45] wl[109] wl[46] wl[110] wl[47] wl[111] wl[48] wl[112] wl[49] wl[113] wl[50] wl[114] wl[51] wl[115] wl[52] wl[116] wl[53] wl[117] wl[54] wl[118] wl[55] wl[119] wl[56] wl[120] wl[57] wl[121] wl[58] wl[122] wl[59] wl[123] wl[60] wl[124] wl[61] wl[125] wl[62] wl[126] wl[63] wl[127]
Xinst0 vss vdd wl[0] wl[32] wl[1] wl[33] wl[2] wl[34] wl[3] wl[35] wl[4] wl[36] wl[5] wl[37] wl[6] wl[38] wl[7] wl[39] wl[8] wl[40] wl[9] wl[41] wl[10] wl[42] wl[11] wl[43] wl[12] wl[44] wl[13] wl[45] wl[14] wl[46] wl[15] wl[47] wl[16] wl[48] wl[17] wl[49] wl[18] wl[50] wl[19] wl[51] wl[20] wl[52] wl[21] wl[53] wl[22] wl[54] wl[23] wl[55] wl[24] wl[56] wl[25] wl[57] wl[26] wl[58] wl[27] wl[59] wl[28] wl[60] wl[29] wl[61] wl[30] wl[62] wl[31] wl[63] SPDICEBulkConnCol_64R
Xinst1 vss vdd wl[64] wl[96] wl[65] wl[97] wl[66] wl[98] wl[67] wl[99] wl[68] wl[100] wl[69] wl[101] wl[70] wl[102] wl[71] wl[103] wl[72] wl[104] wl[73] wl[105] wl[74] wl[106] wl[75] wl[107] wl[76] wl[108] wl[77] wl[109] wl[78] wl[110] wl[79] wl[111] wl[80] wl[112] wl[81] wl[113] wl[82] wl[114] wl[83] wl[115] wl[84] wl[116] wl[85] wl[117] wl[86] wl[118] wl[87] wl[119] wl[88] wl[120] wl[89] wl[121] wl[90] wl[122] wl[91] wl[123] wl[92] wl[124] wl[93] wl[125] wl[94] wl[126] wl[95] wl[127] SPDICEBulkConnCol_64R
.ends SPDICEBulkConnCol_128R

.subckt SPDICEArray_128X16 vss vdd wl[0] wl[1] wl[2] wl[3] wl[4] wl[5] wl[6] wl[7] wl[8] wl[9] wl[10] wl[11] wl[12] wl[13] wl[14] wl[15] wl[16] wl[17] wl[18] wl[19] wl[20] wl[21] wl[22] wl[23] wl[24] wl[25] wl[26] wl[27] wl[28] wl[29] wl[30] wl[31] wl[32] wl[33] wl[34] wl[35] wl[36] wl[37] wl[38] wl[39] wl[40] wl[41] wl[42] wl[43] wl[44] wl[45] wl[46] wl[47] wl[48] wl[49] wl[50] wl[51] wl[52] wl[53] wl[54] wl[55] wl[56] wl[57] wl[58] wl[59] wl[60] wl[61] wl[62] wl[63] wl[64] wl[65] wl[66] wl[67] wl[68] wl[69] wl[70] wl[71] wl[72] wl[73] wl[74] wl[75] wl[76] wl[77] wl[78] wl[79] wl[80] wl[81] wl[82] wl[83] wl[84] wl[85] wl[86] wl[87] wl[88] wl[89] wl[90] wl[91] wl[92] wl[93] wl[94] wl[95] wl[96] wl[97] wl[98] wl[99] wl[100] wl[101] wl[102] wl[103] wl[104] wl[105] wl[106] wl[107] wl[108] wl[109] wl[110] wl[111] wl[112] wl[113] wl[114] wl[115] wl[116] wl[117] wl[118] wl[119] wl[120] wl[121] wl[122] wl[123] wl[124] wl[125] wl[126] wl[127] bl[0] bl_n[0] bl[1] bl_n[1] bl[2] bl_n[2] bl[3] bl_n[3] bl[4] bl_n[4] bl[5] bl_n[5] bl[6] bl_n[6] bl[7] bl_n[7] bl[8] bl_n[8] bl[9] bl_n[9] bl[10] bl_n[10] bl[11] bl_n[11] bl[12] bl_n[12] bl[13] bl_n[13] bl[14] bl_n[14] bl[15] bl_n[15]
Xinst0x0 vss vss vdd vdd wl[0] wl[1] wl[2] wl[3] wl[4] wl[5] wl[6] wl[7] wl[8] wl[9] wl[10] wl[11] wl[12] wl[13] wl[14] wl[15] wl[16] wl[17] wl[18] wl[19] wl[20] wl[21] wl[22] wl[23] wl[24] wl[25] wl[26] wl[27] wl[28] wl[29] wl[30] wl[31] wl[32] wl[33] wl[34] wl[35] wl[36] wl[37] wl[38] wl[39] wl[40] wl[41] wl[42] wl[43] wl[44] wl[45] wl[46] wl[47] wl[48] wl[49] wl[50] wl[51] wl[52] wl[53] wl[54] wl[55] wl[56] wl[57] wl[58] wl[59] wl[60] wl[61] wl[62] wl[63] wl[64] wl[65] wl[66] wl[67] wl[68] wl[69] wl[70] wl[71] wl[72] wl[73] wl[74] wl[75] wl[76] wl[77] wl[78] wl[79] wl[80] wl[81] wl[82] wl[83] wl[84] wl[85] wl[86] wl[87] wl[88] wl[89] wl[90] wl[91] wl[92] wl[93] wl[94] wl[95] wl[96] wl[97] wl[98] wl[99] wl[100] wl[101] wl[102] wl[103] wl[104] wl[105] wl[106] wl[107] wl[108] wl[109] wl[110] wl[111] wl[112] wl[113] wl[114] wl[115] wl[116] wl[117] wl[118] wl[119] wl[120] wl[121] wl[122] wl[123] wl[124] wl[125] wl[126] wl[127] bl[0] bl_n[0] bl[1] bl_n[1] bl[2] bl_n[2] bl[3] bl_n[3] bl[4] bl_n[4] bl[5] bl_n[5] bl[6] bl_n[6] bl[7] bl_n[7] SPDICEArray_128X8
Xinst0x1 vss vss vdd vdd wl[0] wl[1] wl[2] wl[3] wl[4] wl[5] wl[6] wl[7] wl[8] wl[9] wl[10] wl[11] wl[12] wl[13] wl[14] wl[15] wl[16] wl[17] wl[18] wl[19] wl[20] wl[21] wl[22] wl[23] wl[24] wl[25] wl[26] wl[27] wl[28] wl[29] wl[30] wl[31] wl[32] wl[33] wl[34] wl[35] wl[36] wl[37] wl[38] wl[39] wl[40] wl[41] wl[42] wl[43] wl[44] wl[45] wl[46] wl[47] wl[48] wl[49] wl[50] wl[51] wl[52] wl[53] wl[54] wl[55] wl[56] wl[57] wl[58] wl[59] wl[60] wl[61] wl[62] wl[63] wl[64] wl[65] wl[66] wl[67] wl[68] wl[69] wl[70] wl[71] wl[72] wl[73] wl[74] wl[75] wl[76] wl[77] wl[78] wl[79] wl[80] wl[81] wl[82] wl[83] wl[84] wl[85] wl[86] wl[87] wl[88] wl[89] wl[90] wl[91] wl[92] wl[93] wl[94] wl[95] wl[96] wl[97] wl[98] wl[99] wl[100] wl[101] wl[102] wl[103] wl[104] wl[105] wl[106] wl[107] wl[108] wl[109] wl[110] wl[111] wl[112] wl[113] wl[114] wl[115] wl[116] wl[117] wl[118] wl[119] wl[120] wl[121] wl[122] wl[123] wl[124] wl[125] wl[126] wl[127] bl[8] bl_n[8] bl[9] bl_n[9] bl[10] bl_n[10] bl[11] bl_n[11] bl[12] bl_n[12] bl[13] bl_n[13] bl[14] bl_n[14] bl[15] bl_n[15] SPDICEArray_128X8
Xbccol vss vdd wl[0] wl[64] wl[1] wl[65] wl[2] wl[66] wl[3] wl[67] wl[4] wl[68] wl[5] wl[69] wl[6] wl[70] wl[7] wl[71] wl[8] wl[72] wl[9] wl[73] wl[10] wl[74] wl[11] wl[75] wl[12] wl[76] wl[13] wl[77] wl[14] wl[78] wl[15] wl[79] wl[16] wl[80] wl[17] wl[81] wl[18] wl[82] wl[19] wl[83] wl[20] wl[84] wl[21] wl[85] wl[22] wl[86] wl[23] wl[87] wl[24] wl[88] wl[25] wl[89] wl[26] wl[90] wl[27] wl[91] wl[28] wl[92] wl[29] wl[93] wl[30] wl[94] wl[31] wl[95] wl[32] wl[96] wl[33] wl[97] wl[34] wl[98] wl[35] wl[99] wl[36] wl[100] wl[37] wl[101] wl[38] wl[102] wl[39] wl[103] wl[40] wl[104] wl[41] wl[105] wl[42] wl[106] wl[43] wl[107] wl[44] wl[108] wl[45] wl[109] wl[46] wl[110] wl[47] wl[111] wl[48] wl[112] wl[49] wl[113] wl[50] wl[114] wl[51] wl[115] wl[52] wl[116] wl[53] wl[117] wl[54] wl[118] wl[55] wl[119] wl[56] wl[120] wl[57] wl[121] wl[58] wl[122] wl[59] wl[123] wl[60] wl[124] wl[61] wl[125] wl[62] wl[126] wl[63] wl[127] SPDICEBulkConnCol_128R
.ends SPDICEArray_128X16

.subckt SPDICEArray_128X32BC vss vdd wl[0] wl[1] wl[2] wl[3] wl[4] wl[5] wl[6] wl[7] wl[8] wl[9] wl[10] wl[11] wl[12] wl[13] wl[14] wl[15] wl[16] wl[17] wl[18] wl[19] wl[20] wl[21] wl[22] wl[23] wl[24] wl[25] wl[26] wl[27] wl[28] wl[29] wl[30] wl[31] wl[32] wl[33] wl[34] wl[35] wl[36] wl[37] wl[38] wl[39] wl[40] wl[41] wl[42] wl[43] wl[44] wl[45] wl[46] wl[47] wl[48] wl[49] wl[50] wl[51] wl[52] wl[53] wl[54] wl[55] wl[56] wl[57] wl[58] wl[59] wl[60] wl[61] wl[62] wl[63] wl[64] wl[65] wl[66] wl[67] wl[68] wl[69] wl[70] wl[71] wl[72] wl[73] wl[74] wl[75] wl[76] wl[77] wl[78] wl[79] wl[80] wl[81] wl[82] wl[83] wl[84] wl[85] wl[86] wl[87] wl[88] wl[89] wl[90] wl[91] wl[92] wl[93] wl[94] wl[95] wl[96] wl[97] wl[98] wl[99] wl[100] wl[101] wl[102] wl[103] wl[104] wl[105] wl[106] wl[107] wl[108] wl[109] wl[110] wl[111] wl[112] wl[113] wl[114] wl[115] wl[116] wl[117] wl[118] wl[119] wl[120] wl[121] wl[122] wl[123] wl[124] wl[125] wl[126] wl[127] bl[0] bl_n[0] bl[1] bl_n[1] bl[2] bl_n[2] bl[3] bl_n[3] bl[4] bl_n[4] bl[5] bl_n[5] bl[6] bl_n[6] bl[7] bl_n[7] bl[8] bl_n[8] bl[9] bl_n[9] bl[10] bl_n[10] bl[11] bl_n[11] bl[12] bl_n[12] bl[13] bl_n[13] bl[14] bl_n[14] bl[15] bl_n[15] bl[16] bl_n[16] bl[17] bl_n[17] bl[18] bl_n[18] bl[19] bl_n[19] bl[20] bl_n[20] bl[21] bl_n[21] bl[22] bl_n[22] bl[23] bl_n[23] bl[24] bl_n[24] bl[25] bl_n[25] bl[26] bl_n[26] bl[27] bl_n[27] bl[28] bl_n[28] bl[29] bl_n[29] bl[30] bl_n[30] bl[31] bl_n[31]
Xinst0x0 vss vdd wl[0] wl[1] wl[2] wl[3] wl[4] wl[5] wl[6] wl[7] wl[8] wl[9] wl[10] wl[11] wl[12] wl[13] wl[14] wl[15] wl[16] wl[17] wl[18] wl[19] wl[20] wl[21] wl[22] wl[23] wl[24] wl[25] wl[26] wl[27] wl[28] wl[29] wl[30] wl[31] wl[32] wl[33] wl[34] wl[35] wl[36] wl[37] wl[38] wl[39] wl[40] wl[41] wl[42] wl[43] wl[44] wl[45] wl[46] wl[47] wl[48] wl[49] wl[50] wl[51] wl[52] wl[53] wl[54] wl[55] wl[56] wl[57] wl[58] wl[59] wl[60] wl[61] wl[62] wl[63] wl[64] wl[65] wl[66] wl[67] wl[68] wl[69] wl[70] wl[71] wl[72] wl[73] wl[74] wl[75] wl[76] wl[77] wl[78] wl[79] wl[80] wl[81] wl[82] wl[83] wl[84] wl[85] wl[86] wl[87] wl[88] wl[89] wl[90] wl[91] wl[92] wl[93] wl[94] wl[95] wl[96] wl[97] wl[98] wl[99] wl[100] wl[101] wl[102] wl[103] wl[104] wl[105] wl[106] wl[107] wl[108] wl[109] wl[110] wl[111] wl[112] wl[113] wl[114] wl[115] wl[116] wl[117] wl[118] wl[119] wl[120] wl[121] wl[122] wl[123] wl[124] wl[125] wl[126] wl[127] bl[0] bl_n[0] bl[1] bl_n[1] bl[2] bl_n[2] bl[3] bl_n[3] bl[4] bl_n[4] bl[5] bl_n[5] bl[6] bl_n[6] bl[7] bl_n[7] bl[8] bl_n[8] bl[9] bl_n[9] bl[10] bl_n[10] bl[11] bl_n[11] bl[12] bl_n[12] bl[13] bl_n[13] bl[14] bl_n[14] bl[15] bl_n[15] SPDICEArray_128X16
Xinst0x1 vss vdd wl[0] wl[1] wl[2] wl[3] wl[4] wl[5] wl[6] wl[7] wl[8] wl[9] wl[10] wl[11] wl[12] wl[13] wl[14] wl[15] wl[16] wl[17] wl[18] wl[19] wl[20] wl[21] wl[22] wl[23] wl[24] wl[25] wl[26] wl[27] wl[28] wl[29] wl[30] wl[31] wl[32] wl[33] wl[34] wl[35] wl[36] wl[37] wl[38] wl[39] wl[40] wl[41] wl[42] wl[43] wl[44] wl[45] wl[46] wl[47] wl[48] wl[49] wl[50] wl[51] wl[52] wl[53] wl[54] wl[55] wl[56] wl[57] wl[58] wl[59] wl[60] wl[61] wl[62] wl[63] wl[64] wl[65] wl[66] wl[67] wl[68] wl[69] wl[70] wl[71] wl[72] wl[73] wl[74] wl[75] wl[76] wl[77] wl[78] wl[79] wl[80] wl[81] wl[82] wl[83] wl[84] wl[85] wl[86] wl[87] wl[88] wl[89] wl[90] wl[91] wl[92] wl[93] wl[94] wl[95] wl[96] wl[97] wl[98] wl[99] wl[100] wl[101] wl[102] wl[103] wl[104] wl[105] wl[106] wl[107] wl[108] wl[109] wl[110] wl[111] wl[112] wl[113] wl[114] wl[115] wl[116] wl[117] wl[118] wl[119] wl[120] wl[121] wl[122] wl[123] wl[124] wl[125] wl[126] wl[127] bl[16] bl_n[16] bl[17] bl_n[17] bl[18] bl_n[18] bl[19] bl_n[19] bl[20] bl_n[20] bl[21] bl_n[21] bl[22] bl_n[22] bl[23] bl_n[23] bl[24] bl_n[24] bl[25] bl_n[25] bl[26] bl_n[26] bl[27] bl_n[27] bl[28] bl_n[28] bl[29] bl_n[29] bl[30] bl_n[30] bl[31] bl_n[31] SPDICEArray_128X16
Xbccol vss vdd wl[0] wl[64] wl[1] wl[65] wl[2] wl[66] wl[3] wl[67] wl[4] wl[68] wl[5] wl[69] wl[6] wl[70] wl[7] wl[71] wl[8] wl[72] wl[9] wl[73] wl[10] wl[74] wl[11] wl[75] wl[12] wl[76] wl[13] wl[77] wl[14] wl[78] wl[15] wl[79] wl[16] wl[80] wl[17] wl[81] wl[18] wl[82] wl[19] wl[83] wl[20] wl[84] wl[21] wl[85] wl[22] wl[86] wl[23] wl[87] wl[24] wl[88] wl[25] wl[89] wl[26] wl[90] wl[27] wl[91] wl[28] wl[92] wl[29] wl[93] wl[30] wl[94] wl[31] wl[95] wl[32] wl[96] wl[33] wl[97] wl[34] wl[98] wl[35] wl[99] wl[36] wl[100] wl[37] wl[101] wl[38] wl[102] wl[39] wl[103] wl[40] wl[104] wl[41] wl[105] wl[42] wl[106] wl[43] wl[107] wl[44] wl[108] wl[45] wl[109] wl[46] wl[110] wl[47] wl[111] wl[48] wl[112] wl[49] wl[113] wl[50] wl[114] wl[51] wl[115] wl[52] wl[116] wl[53] wl[117] wl[54] wl[118] wl[55] wl[119] wl[56] wl[120] wl[57] wl[121] wl[58] wl[122] wl[59] wl[123] wl[60] wl[124] wl[61] wl[125] wl[62] wl[126] wl[63] wl[127] SPDICEBulkConnCol_128R
Xleftbcrow vss vdd wl[0] wl[64] wl[1] wl[65] wl[2] wl[66] wl[3] wl[67] wl[4] wl[68] wl[5] wl[69] wl[6] wl[70] wl[7] wl[71] wl[8] wl[72] wl[9] wl[73] wl[10] wl[74] wl[11] wl[75] wl[12] wl[76] wl[13] wl[77] wl[14] wl[78] wl[15] wl[79] wl[16] wl[80] wl[17] wl[81] wl[18] wl[82] wl[19] wl[83] wl[20] wl[84] wl[21] wl[85] wl[22] wl[86] wl[23] wl[87] wl[24] wl[88] wl[25] wl[89] wl[26] wl[90] wl[27] wl[91] wl[28] wl[92] wl[29] wl[93] wl[30] wl[94] wl[31] wl[95] wl[32] wl[96] wl[33] wl[97] wl[34] wl[98] wl[35] wl[99] wl[36] wl[100] wl[37] wl[101] wl[38] wl[102] wl[39] wl[103] wl[40] wl[104] wl[41] wl[105] wl[42] wl[106] wl[43] wl[107] wl[44] wl[108] wl[45] wl[109] wl[46] wl[110] wl[47] wl[111] wl[48] wl[112] wl[49] wl[113] wl[50] wl[114] wl[51] wl[115] wl[52] wl[116] wl[53] wl[117] wl[54] wl[118] wl[55] wl[119] wl[56] wl[120] wl[57] wl[121] wl[58] wl[122] wl[59] wl[123] wl[60] wl[124] wl[61] wl[125] wl[62] wl[126] wl[63] wl[127] SPDICEBulkConnCol_128R
Xrightbcrow vss vdd wl[0] wl[64] wl[1] wl[65] wl[2] wl[66] wl[3] wl[67] wl[4] wl[68] wl[5] wl[69] wl[6] wl[70] wl[7] wl[71] wl[8] wl[72] wl[9] wl[73] wl[10] wl[74] wl[11] wl[75] wl[12] wl[76] wl[13] wl[77] wl[14] wl[78] wl[15] wl[79] wl[16] wl[80] wl[17] wl[81] wl[18] wl[82] wl[19] wl[83] wl[20] wl[84] wl[21] wl[85] wl[22] wl[86] wl[23] wl[87] wl[24] wl[88] wl[25] wl[89] wl[26] wl[90] wl[27] wl[91] wl[28] wl[92] wl[29] wl[93] wl[30] wl[94] wl[31] wl[95] wl[32] wl[96] wl[33] wl[97] wl[34] wl[98] wl[35] wl[99] wl[36] wl[100] wl[37] wl[101] wl[38] wl[102] wl[39] wl[103] wl[40] wl[104] wl[41] wl[105] wl[42] wl[106] wl[43] wl[107] wl[44] wl[108] wl[45] wl[109] wl[46] wl[110] wl[47] wl[111] wl[48] wl[112] wl[49] wl[113] wl[50] wl[114] wl[51] wl[115] wl[52] wl[116] wl[53] wl[117] wl[54] wl[118] wl[55] wl[119] wl[56] wl[120] wl[57] wl[121] wl[58] wl[122] wl[59] wl[123] wl[60] wl[124] wl[61] wl[125] wl[62] wl[126] wl[63] wl[127] SPDICEBulkConnCol_128R
.ends SPDICEArray_128X32BC

.subckt SPDICEPrecharge_26L100WM vdd nwell bl bl_n precharge_n
Xpc1 vdd precharge_n bl nwell sg13_lv_pmos l=1.3e-07 w=5e-07
Xpc2 bl precharge_n bl_n nwell sg13_lv_pmos l=1.3e-07 w=5e-07
Xpc3 bl_n precharge_n vdd nwell sg13_lv_pmos l=1.3e-07 w=5e-07
.ends SPDICEPrecharge_26L100WM

.subckt SPDICEColMux_4MN26L580W1R bl[0] bl_n[0] mux[0] bl[1] bl_n[1] mux[1] bl[2] bl_n[2] mux[2] bl[3] bl_n[3] mux[3] vss muxbl muxbl_n
Xpgbl0 muxbl mux[0] bl[0] vss sg13_lv_nmos l=1.3e-07 w=2.9e-06
Xpgbln0 bl_n[0] mux[0] muxbl_n vss sg13_lv_nmos l=1.3e-07 w=2.9e-06
Xpgbl1 bl[1] mux[1] muxbl vss sg13_lv_nmos l=1.3e-07 w=2.9e-06
Xpgbln1 muxbl_n mux[1] bl_n[1] vss sg13_lv_nmos l=1.3e-07 w=2.9e-06
Xpgbl2 muxbl mux[2] bl[2] vss sg13_lv_nmos l=1.3e-07 w=2.9e-06
Xpgbln2 bl_n[2] mux[2] muxbl_n vss sg13_lv_nmos l=1.3e-07 w=2.9e-06
Xpgbl3 bl[3] mux[3] muxbl vss sg13_lv_nmos l=1.3e-07 w=2.9e-06
Xpgbln3 muxbl_n mux[3] bl_n[3] vss sg13_lv_nmos l=1.3e-07 w=2.9e-06
.ends SPDICEColMux_4MN26L580W1R

.subckt SPDICEReadWrite_CM4MN26L580W1R_WD26L380W vss vdd d q bl bl_n clk we_n
Xsenseamp vdd vss bl_n bl q noconn nsnrlatch_x1
Xd_ff vdd vss d clk d_l dff_x1
Xd_inv vdd vss d_l d_n inv_x0
Xnora vdd vss bl_pd_g d_l we_n nor2_x0
Xnorb vdd vss bln_pd_g d_n we_n nor2_x0
Xbl_pd bl bl_pd_g vss vss sg13_lv_nmos l=1.3e-07 w=1.9e-06
Xbln_pd vss bln_pd_g bl_n vss sg13_lv_nmos l=1.3e-07 w=1.9e-06
.ends SPDICEReadWrite_CM4MN26L580W1R_WD26L380W

.subckt SPDICEClockWE vss vdd clkup clkdown we we_en we_n
Xclkbuf vdd vss clkup clkdown buf_x2
Xweff vdd vss we clkdown we_l dff_x1
Xwenand vdd vss we_n we_l we_en nand2_x0
.ends SPDICEClockWE

.subckt SPDICEPCSpacing_26L100W vdd nwell
.ends SPDICEPCSpacing_26L100W

.subckt SPDICEColPeriph8B_PC26L100W_CM4MN26L580W1R vss vdd nwell clk precharge_n we we_en q[0] d[0] bl[0] bl_n[0] bl[1] bl_n[1] bl[2] bl_n[2] bl[3] bl_n[3] q[1] d[1] bl[4] bl_n[4] bl[5] bl_n[5] bl[6] bl_n[6] bl[7] bl_n[7] q[2] d[2] bl[8] bl_n[8] bl[9] bl_n[9] bl[10] bl_n[10] bl[11] bl_n[11] q[3] d[3] bl[12] bl_n[12] bl[13] bl_n[13] bl[14] bl_n[14] bl[15] bl_n[15] q[4] d[4] bl[16] bl_n[16] bl[17] bl_n[17] bl[18] bl_n[18] bl[19] bl_n[19] q[5] d[5] bl[20] bl_n[20] bl[21] bl_n[21] bl[22] bl_n[22] bl[23] bl_n[23] q[6] d[6] bl[24] bl_n[24] bl[25] bl_n[25] bl[26] bl_n[26] bl[27] bl_n[27] q[7] d[7] bl[28] bl_n[28] bl[29] bl_n[29] bl[30] bl_n[30] bl[31] bl_n[31] mux[0] mux[1] mux[2] mux[3]
Xprecharge[0] vdd nwell bl[0] bl_n[0] precharge_n SPDICEPrecharge_26L100WM
Xprecharge[1] vdd nwell bl[1] bl_n[1] precharge_n SPDICEPrecharge_26L100WM
Xprecharge[2] vdd nwell bl[2] bl_n[2] precharge_n SPDICEPrecharge_26L100WM
Xprecharge[3] vdd nwell bl[3] bl_n[3] precharge_n SPDICEPrecharge_26L100WM
Xprecharge[4] vdd nwell bl[4] bl_n[4] precharge_n SPDICEPrecharge_26L100WM
Xprecharge[5] vdd nwell bl[5] bl_n[5] precharge_n SPDICEPrecharge_26L100WM
Xprecharge[6] vdd nwell bl[6] bl_n[6] precharge_n SPDICEPrecharge_26L100WM
Xprecharge[7] vdd nwell bl[7] bl_n[7] precharge_n SPDICEPrecharge_26L100WM
Xprecharge[8] vdd nwell bl[8] bl_n[8] precharge_n SPDICEPrecharge_26L100WM
Xprecharge[9] vdd nwell bl[9] bl_n[9] precharge_n SPDICEPrecharge_26L100WM
Xprecharge[10] vdd nwell bl[10] bl_n[10] precharge_n SPDICEPrecharge_26L100WM
Xprecharge[11] vdd nwell bl[11] bl_n[11] precharge_n SPDICEPrecharge_26L100WM
Xprecharge[12] vdd nwell bl[12] bl_n[12] precharge_n SPDICEPrecharge_26L100WM
Xprecharge[13] vdd nwell bl[13] bl_n[13] precharge_n SPDICEPrecharge_26L100WM
Xprecharge[14] vdd nwell bl[14] bl_n[14] precharge_n SPDICEPrecharge_26L100WM
Xprecharge[15] vdd nwell bl[15] bl_n[15] precharge_n SPDICEPrecharge_26L100WM
Xprecharge[16] vdd nwell bl[16] bl_n[16] precharge_n SPDICEPrecharge_26L100WM
Xprecharge[17] vdd nwell bl[17] bl_n[17] precharge_n SPDICEPrecharge_26L100WM
Xprecharge[18] vdd nwell bl[18] bl_n[18] precharge_n SPDICEPrecharge_26L100WM
Xprecharge[19] vdd nwell bl[19] bl_n[19] precharge_n SPDICEPrecharge_26L100WM
Xprecharge[20] vdd nwell bl[20] bl_n[20] precharge_n SPDICEPrecharge_26L100WM
Xprecharge[21] vdd nwell bl[21] bl_n[21] precharge_n SPDICEPrecharge_26L100WM
Xprecharge[22] vdd nwell bl[22] bl_n[22] precharge_n SPDICEPrecharge_26L100WM
Xprecharge[23] vdd nwell bl[23] bl_n[23] precharge_n SPDICEPrecharge_26L100WM
Xprecharge[24] vdd nwell bl[24] bl_n[24] precharge_n SPDICEPrecharge_26L100WM
Xprecharge[25] vdd nwell bl[25] bl_n[25] precharge_n SPDICEPrecharge_26L100WM
Xprecharge[26] vdd nwell bl[26] bl_n[26] precharge_n SPDICEPrecharge_26L100WM
Xprecharge[27] vdd nwell bl[27] bl_n[27] precharge_n SPDICEPrecharge_26L100WM
Xprecharge[28] vdd nwell bl[28] bl_n[28] precharge_n SPDICEPrecharge_26L100WM
Xprecharge[29] vdd nwell bl[29] bl_n[29] precharge_n SPDICEPrecharge_26L100WM
Xprecharge[30] vdd nwell bl[30] bl_n[30] precharge_n SPDICEPrecharge_26L100WM
Xprecharge[31] vdd nwell bl[31] bl_n[31] precharge_n SPDICEPrecharge_26L100WM
Xcolmux[0] bl[0] bl_n[0] mux[0] bl[1] bl_n[1] mux[1] bl[2] bl_n[2] mux[2] bl[3] bl_n[3] mux[3] vss muxbl[0] muxbl_n[0] SPDICEColMux_4MN26L580W1R
Xcolmux[1] bl[4] bl_n[4] mux[0] bl[5] bl_n[5] mux[1] bl[6] bl_n[6] mux[2] bl[7] bl_n[7] mux[3] vss muxbl[1] muxbl_n[1] SPDICEColMux_4MN26L580W1R
Xcolmux[2] bl[8] bl_n[8] mux[0] bl[9] bl_n[9] mux[1] bl[10] bl_n[10] mux[2] bl[11] bl_n[11] mux[3] vss muxbl[2] muxbl_n[2] SPDICEColMux_4MN26L580W1R
Xcolmux[3] bl[12] bl_n[12] mux[0] bl[13] bl_n[13] mux[1] bl[14] bl_n[14] mux[2] bl[15] bl_n[15] mux[3] vss muxbl[3] muxbl_n[3] SPDICEColMux_4MN26L580W1R
Xcolmux[4] bl[16] bl_n[16] mux[0] bl[17] bl_n[17] mux[1] bl[18] bl_n[18] mux[2] bl[19] bl_n[19] mux[3] vss muxbl[4] muxbl_n[4] SPDICEColMux_4MN26L580W1R
Xcolmux[5] bl[20] bl_n[20] mux[0] bl[21] bl_n[21] mux[1] bl[22] bl_n[22] mux[2] bl[23] bl_n[23] mux[3] vss muxbl[5] muxbl_n[5] SPDICEColMux_4MN26L580W1R
Xcolmux[6] bl[24] bl_n[24] mux[0] bl[25] bl_n[25] mux[1] bl[26] bl_n[26] mux[2] bl[27] bl_n[27] mux[3] vss muxbl[6] muxbl_n[6] SPDICEColMux_4MN26L580W1R
Xcolmux[7] bl[28] bl_n[28] mux[0] bl[29] bl_n[29] mux[1] bl[30] bl_n[30] mux[2] bl[31] bl_n[31] mux[3] vss muxbl[7] muxbl_n[7] SPDICEColMux_4MN26L580W1R
Xrw[0] vss vdd d[0] q[0] muxbl[0] muxbl_n[0] intclk we_n SPDICEReadWrite_CM4MN26L580W1R_WD26L380W
Xrw[1] vss vdd d[1] q[1] muxbl[1] muxbl_n[1] intclk we_n SPDICEReadWrite_CM4MN26L580W1R_WD26L380W
Xrw[2] vss vdd d[2] q[2] muxbl[2] muxbl_n[2] intclk we_n SPDICEReadWrite_CM4MN26L580W1R_WD26L380W
Xrw[3] vss vdd d[3] q[3] muxbl[3] muxbl_n[3] intclk we_n SPDICEReadWrite_CM4MN26L580W1R_WD26L380W
Xrw[4] vss vdd d[4] q[4] muxbl[4] muxbl_n[4] intclk we_n SPDICEReadWrite_CM4MN26L580W1R_WD26L380W
Xrw[5] vss vdd d[5] q[5] muxbl[5] muxbl_n[5] intclk we_n SPDICEReadWrite_CM4MN26L580W1R_WD26L380W
Xrw[6] vss vdd d[6] q[6] muxbl[6] muxbl_n[6] intclk we_n SPDICEReadWrite_CM4MN26L580W1R_WD26L380W
Xrw[7] vss vdd d[7] q[7] muxbl[7] muxbl_n[7] intclk we_n SPDICEReadWrite_CM4MN26L580W1R_WD26L380W
Xclkwe vss vdd clk intclk we we_en we_n SPDICEClockWE
Xpcspace[0] vdd nwell SPDICEPCSpacing_26L100W
Xpcspace[0] vdd nwell SPDICEPCSpacing_26L100W
Xpcspace[0] vdd nwell SPDICEPCSpacing_26L100W
Xpcspace[0] vdd nwell SPDICEPCSpacing_26L100W
Xpcspace[0] vdd nwell SPDICEPCSpacing_26L100W
.ends SPDICEColPeriph8B_PC26L100W_CM4MN26L580W1R

.subckt SPDICEColumn_128R_CP8B_CM4MN26L580W1R_PC26L100W vss vdd wl[0] wl[1] wl[2] wl[3] wl[4] wl[5] wl[6] wl[7] wl[8] wl[9] wl[10] wl[11] wl[12] wl[13] wl[14] wl[15] wl[16] wl[17] wl[18] wl[19] wl[20] wl[21] wl[22] wl[23] wl[24] wl[25] wl[26] wl[27] wl[28] wl[29] wl[30] wl[31] wl[32] wl[33] wl[34] wl[35] wl[36] wl[37] wl[38] wl[39] wl[40] wl[41] wl[42] wl[43] wl[44] wl[45] wl[46] wl[47] wl[48] wl[49] wl[50] wl[51] wl[52] wl[53] wl[54] wl[55] wl[56] wl[57] wl[58] wl[59] wl[60] wl[61] wl[62] wl[63] wl[64] wl[65] wl[66] wl[67] wl[68] wl[69] wl[70] wl[71] wl[72] wl[73] wl[74] wl[75] wl[76] wl[77] wl[78] wl[79] wl[80] wl[81] wl[82] wl[83] wl[84] wl[85] wl[86] wl[87] wl[88] wl[89] wl[90] wl[91] wl[92] wl[93] wl[94] wl[95] wl[96] wl[97] wl[98] wl[99] wl[100] wl[101] wl[102] wl[103] wl[104] wl[105] wl[106] wl[107] wl[108] wl[109] wl[110] wl[111] wl[112] wl[113] wl[114] wl[115] wl[116] wl[117] wl[118] wl[119] wl[120] wl[121] wl[122] wl[123] wl[124] wl[125] wl[126] wl[127] q[0] d[0] q[1] d[1] q[2] d[2] q[3] d[3] q[4] d[4] q[5] d[5] q[6] d[6] q[7] d[7] we clk we_en precharge_n mux[0] mux[1] mux[2] mux[3]
Xarray vss vdd wl[0] wl[1] wl[2] wl[3] wl[4] wl[5] wl[6] wl[7] wl[8] wl[9] wl[10] wl[11] wl[12] wl[13] wl[14] wl[15] wl[16] wl[17] wl[18] wl[19] wl[20] wl[21] wl[22] wl[23] wl[24] wl[25] wl[26] wl[27] wl[28] wl[29] wl[30] wl[31] wl[32] wl[33] wl[34] wl[35] wl[36] wl[37] wl[38] wl[39] wl[40] wl[41] wl[42] wl[43] wl[44] wl[45] wl[46] wl[47] wl[48] wl[49] wl[50] wl[51] wl[52] wl[53] wl[54] wl[55] wl[56] wl[57] wl[58] wl[59] wl[60] wl[61] wl[62] wl[63] wl[64] wl[65] wl[66] wl[67] wl[68] wl[69] wl[70] wl[71] wl[72] wl[73] wl[74] wl[75] wl[76] wl[77] wl[78] wl[79] wl[80] wl[81] wl[82] wl[83] wl[84] wl[85] wl[86] wl[87] wl[88] wl[89] wl[90] wl[91] wl[92] wl[93] wl[94] wl[95] wl[96] wl[97] wl[98] wl[99] wl[100] wl[101] wl[102] wl[103] wl[104] wl[105] wl[106] wl[107] wl[108] wl[109] wl[110] wl[111] wl[112] wl[113] wl[114] wl[115] wl[116] wl[117] wl[118] wl[119] wl[120] wl[121] wl[122] wl[123] wl[124] wl[125] wl[126] wl[127] bl[0] bl_n[0] bl[1] bl_n[1] bl[2] bl_n[2] bl[3] bl_n[3] bl[4] bl_n[4] bl[5] bl_n[5] bl[6] bl_n[6] bl[7] bl_n[7] bl[8] bl_n[8] bl[9] bl_n[9] bl[10] bl_n[10] bl[11] bl_n[11] bl[12] bl_n[12] bl[13] bl_n[13] bl[14] bl_n[14] bl[15] bl_n[15] bl[16] bl_n[16] bl[17] bl_n[17] bl[18] bl_n[18] bl[19] bl_n[19] bl[20] bl_n[20] bl[21] bl_n[21] bl[22] bl_n[22] bl[23] bl_n[23] bl[24] bl_n[24] bl[25] bl_n[25] bl[26] bl_n[26] bl[27] bl_n[27] bl[28] bl_n[28] bl[29] bl_n[29] bl[30] bl_n[30] bl[31] bl_n[31] SPDICEArray_128X32BC
Xperiph vss vdd vdd clk precharge_n we we_en q[0] d[0] bl[0] bl_n[0] bl[1] bl_n[1] bl[2] bl_n[2] bl[3] bl_n[3] q[1] d[1] bl[4] bl_n[4] bl[5] bl_n[5] bl[6] bl_n[6] bl[7] bl_n[7] q[2] d[2] bl[8] bl_n[8] bl[9] bl_n[9] bl[10] bl_n[10] bl[11] bl_n[11] q[3] d[3] bl[12] bl_n[12] bl[13] bl_n[13] bl[14] bl_n[14] bl[15] bl_n[15] q[4] d[4] bl[16] bl_n[16] bl[17] bl_n[17] bl[18] bl_n[18] bl[19] bl_n[19] q[5] d[5] bl[20] bl_n[20] bl[21] bl_n[21] bl[22] bl_n[22] bl[23] bl_n[23] q[6] d[6] bl[24] bl_n[24] bl[25] bl_n[25] bl[26] bl_n[26] bl[27] bl_n[27] q[7] d[7] bl[28] bl_n[28] bl[29] bl_n[29] bl[30] bl_n[30] bl[31] bl_n[31] mux[0] mux[1] mux[2] mux[3] SPDICEColPeriph8B_PC26L100W_CM4MN26L580W1R
.ends SPDICEColumn_128R_CP8B_CM4MN26L580W1R_PC26L100W

.subckt SPDICEColumnBlock_COL128R_CP8B_CM4MN26L580W1R_PC26L100W_4WE vss vdd clk precharge_n we_en wl[0] wl[1] wl[2] wl[3] wl[4] wl[5] wl[6] wl[7] wl[8] wl[9] wl[10] wl[11] wl[12] wl[13] wl[14] wl[15] wl[16] wl[17] wl[18] wl[19] wl[20] wl[21] wl[22] wl[23] wl[24] wl[25] wl[26] wl[27] wl[28] wl[29] wl[30] wl[31] wl[32] wl[33] wl[34] wl[35] wl[36] wl[37] wl[38] wl[39] wl[40] wl[41] wl[42] wl[43] wl[44] wl[45] wl[46] wl[47] wl[48] wl[49] wl[50] wl[51] wl[52] wl[53] wl[54] wl[55] wl[56] wl[57] wl[58] wl[59] wl[60] wl[61] wl[62] wl[63] wl[64] wl[65] wl[66] wl[67] wl[68] wl[69] wl[70] wl[71] wl[72] wl[73] wl[74] wl[75] wl[76] wl[77] wl[78] wl[79] wl[80] wl[81] wl[82] wl[83] wl[84] wl[85] wl[86] wl[87] wl[88] wl[89] wl[90] wl[91] wl[92] wl[93] wl[94] wl[95] wl[96] wl[97] wl[98] wl[99] wl[100] wl[101] wl[102] wl[103] wl[104] wl[105] wl[106] wl[107] wl[108] wl[109] wl[110] wl[111] wl[112] wl[113] wl[114] wl[115] wl[116] wl[117] wl[118] wl[119] wl[120] wl[121] wl[122] wl[123] wl[124] wl[125] wl[126] wl[127] mux[0] mux[1] mux[2] mux[3] we[0] q[0] d[0] q[1] d[1] q[2] d[2] q[3] d[3] q[4] d[4] q[5] d[5] q[6] d[6] q[7] d[7] we[1] q[8] d[8] q[9] d[9] q[10] d[10] q[11] d[11] q[12] d[12] q[13] d[13] q[14] d[14] q[15] d[15] we[2] q[16] d[16] q[17] d[17] q[18] d[18] q[19] d[19] q[20] d[20] q[21] d[21] q[22] d[22] q[23] d[23] we[3] q[24] d[24] q[25] d[25] q[26] d[26] q[27] d[27] q[28] d[28] q[29] d[29] q[30] d[30] q[31] d[31]
Xcolumn[0] vss vdd wl[0] wl[1] wl[2] wl[3] wl[4] wl[5] wl[6] wl[7] wl[8] wl[9] wl[10] wl[11] wl[12] wl[13] wl[14] wl[15] wl[16] wl[17] wl[18] wl[19] wl[20] wl[21] wl[22] wl[23] wl[24] wl[25] wl[26] wl[27] wl[28] wl[29] wl[30] wl[31] wl[32] wl[33] wl[34] wl[35] wl[36] wl[37] wl[38] wl[39] wl[40] wl[41] wl[42] wl[43] wl[44] wl[45] wl[46] wl[47] wl[48] wl[49] wl[50] wl[51] wl[52] wl[53] wl[54] wl[55] wl[56] wl[57] wl[58] wl[59] wl[60] wl[61] wl[62] wl[63] wl[64] wl[65] wl[66] wl[67] wl[68] wl[69] wl[70] wl[71] wl[72] wl[73] wl[74] wl[75] wl[76] wl[77] wl[78] wl[79] wl[80] wl[81] wl[82] wl[83] wl[84] wl[85] wl[86] wl[87] wl[88] wl[89] wl[90] wl[91] wl[92] wl[93] wl[94] wl[95] wl[96] wl[97] wl[98] wl[99] wl[100] wl[101] wl[102] wl[103] wl[104] wl[105] wl[106] wl[107] wl[108] wl[109] wl[110] wl[111] wl[112] wl[113] wl[114] wl[115] wl[116] wl[117] wl[118] wl[119] wl[120] wl[121] wl[122] wl[123] wl[124] wl[125] wl[126] wl[127] q[0] d[0] q[1] d[1] q[2] d[2] q[3] d[3] q[4] d[4] q[5] d[5] q[6] d[6] q[7] d[7] we[0] clk we_en precharge_n mux[0] mux[1] mux[2] mux[3] SPDICEColumn_128R_CP8B_CM4MN26L580W1R_PC26L100W
Xcolumn[1] vss vdd wl[0] wl[1] wl[2] wl[3] wl[4] wl[5] wl[6] wl[7] wl[8] wl[9] wl[10] wl[11] wl[12] wl[13] wl[14] wl[15] wl[16] wl[17] wl[18] wl[19] wl[20] wl[21] wl[22] wl[23] wl[24] wl[25] wl[26] wl[27] wl[28] wl[29] wl[30] wl[31] wl[32] wl[33] wl[34] wl[35] wl[36] wl[37] wl[38] wl[39] wl[40] wl[41] wl[42] wl[43] wl[44] wl[45] wl[46] wl[47] wl[48] wl[49] wl[50] wl[51] wl[52] wl[53] wl[54] wl[55] wl[56] wl[57] wl[58] wl[59] wl[60] wl[61] wl[62] wl[63] wl[64] wl[65] wl[66] wl[67] wl[68] wl[69] wl[70] wl[71] wl[72] wl[73] wl[74] wl[75] wl[76] wl[77] wl[78] wl[79] wl[80] wl[81] wl[82] wl[83] wl[84] wl[85] wl[86] wl[87] wl[88] wl[89] wl[90] wl[91] wl[92] wl[93] wl[94] wl[95] wl[96] wl[97] wl[98] wl[99] wl[100] wl[101] wl[102] wl[103] wl[104] wl[105] wl[106] wl[107] wl[108] wl[109] wl[110] wl[111] wl[112] wl[113] wl[114] wl[115] wl[116] wl[117] wl[118] wl[119] wl[120] wl[121] wl[122] wl[123] wl[124] wl[125] wl[126] wl[127] q[8] d[8] q[9] d[9] q[10] d[10] q[11] d[11] q[12] d[12] q[13] d[13] q[14] d[14] q[15] d[15] we[1] clk we_en precharge_n mux[0] mux[1] mux[2] mux[3] SPDICEColumn_128R_CP8B_CM4MN26L580W1R_PC26L100W
Xcolumn[2] vss vdd wl[0] wl[1] wl[2] wl[3] wl[4] wl[5] wl[6] wl[7] wl[8] wl[9] wl[10] wl[11] wl[12] wl[13] wl[14] wl[15] wl[16] wl[17] wl[18] wl[19] wl[20] wl[21] wl[22] wl[23] wl[24] wl[25] wl[26] wl[27] wl[28] wl[29] wl[30] wl[31] wl[32] wl[33] wl[34] wl[35] wl[36] wl[37] wl[38] wl[39] wl[40] wl[41] wl[42] wl[43] wl[44] wl[45] wl[46] wl[47] wl[48] wl[49] wl[50] wl[51] wl[52] wl[53] wl[54] wl[55] wl[56] wl[57] wl[58] wl[59] wl[60] wl[61] wl[62] wl[63] wl[64] wl[65] wl[66] wl[67] wl[68] wl[69] wl[70] wl[71] wl[72] wl[73] wl[74] wl[75] wl[76] wl[77] wl[78] wl[79] wl[80] wl[81] wl[82] wl[83] wl[84] wl[85] wl[86] wl[87] wl[88] wl[89] wl[90] wl[91] wl[92] wl[93] wl[94] wl[95] wl[96] wl[97] wl[98] wl[99] wl[100] wl[101] wl[102] wl[103] wl[104] wl[105] wl[106] wl[107] wl[108] wl[109] wl[110] wl[111] wl[112] wl[113] wl[114] wl[115] wl[116] wl[117] wl[118] wl[119] wl[120] wl[121] wl[122] wl[123] wl[124] wl[125] wl[126] wl[127] q[16] d[16] q[17] d[17] q[18] d[18] q[19] d[19] q[20] d[20] q[21] d[21] q[22] d[22] q[23] d[23] we[2] clk we_en precharge_n mux[0] mux[1] mux[2] mux[3] SPDICEColumn_128R_CP8B_CM4MN26L580W1R_PC26L100W
Xcolumn[3] vss vdd wl[0] wl[1] wl[2] wl[3] wl[4] wl[5] wl[6] wl[7] wl[8] wl[9] wl[10] wl[11] wl[12] wl[13] wl[14] wl[15] wl[16] wl[17] wl[18] wl[19] wl[20] wl[21] wl[22] wl[23] wl[24] wl[25] wl[26] wl[27] wl[28] wl[29] wl[30] wl[31] wl[32] wl[33] wl[34] wl[35] wl[36] wl[37] wl[38] wl[39] wl[40] wl[41] wl[42] wl[43] wl[44] wl[45] wl[46] wl[47] wl[48] wl[49] wl[50] wl[51] wl[52] wl[53] wl[54] wl[55] wl[56] wl[57] wl[58] wl[59] wl[60] wl[61] wl[62] wl[63] wl[64] wl[65] wl[66] wl[67] wl[68] wl[69] wl[70] wl[71] wl[72] wl[73] wl[74] wl[75] wl[76] wl[77] wl[78] wl[79] wl[80] wl[81] wl[82] wl[83] wl[84] wl[85] wl[86] wl[87] wl[88] wl[89] wl[90] wl[91] wl[92] wl[93] wl[94] wl[95] wl[96] wl[97] wl[98] wl[99] wl[100] wl[101] wl[102] wl[103] wl[104] wl[105] wl[106] wl[107] wl[108] wl[109] wl[110] wl[111] wl[112] wl[113] wl[114] wl[115] wl[116] wl[117] wl[118] wl[119] wl[120] wl[121] wl[122] wl[123] wl[124] wl[125] wl[126] wl[127] q[24] d[24] q[25] d[25] q[26] d[26] q[27] d[27] q[28] d[28] q[29] d[29] q[30] d[30] q[31] d[31] we[3] clk we_en precharge_n mux[0] mux[1] mux[2] mux[3] SPDICEColumn_128R_CP8B_CM4MN26L580W1R_PC26L100W
.ends SPDICEColumnBlock_COL128R_CP8B_CM4MN26L580W1R_PC26L100W_4WE

.subckt SPDICEWLDriver_N26L400WP26L800W vss vdd wl_n wl_drive
Xnmos1 vss wl_n wl_drive vss sg13_lv_nmos l=1.3e-07 w=2e-06
Xnmos2 wl_drive wl_n vss vss sg13_lv_nmos l=1.3e-07 w=2e-06
Xpmos1 vdd wl_n wl_drive vdd sg13_lv_pmos l=1.3e-07 w=4e-06
Xpmos2 wl_drive wl_n vdd vdd sg13_lv_pmos l=1.3e-07 w=4e-06
.ends SPDICEWLDriver_N26L400WP26L800W

.subckt SPDICEWLDriverCol_128RN26L400WP26L800W vss vdd wl[0] wl_n[0] wl[1] wl_n[1] wl[2] wl_n[2] wl[3] wl_n[3] wl[4] wl_n[4] wl[5] wl_n[5] wl[6] wl_n[6] wl[7] wl_n[7] wl[8] wl_n[8] wl[9] wl_n[9] wl[10] wl_n[10] wl[11] wl_n[11] wl[12] wl_n[12] wl[13] wl_n[13] wl[14] wl_n[14] wl[15] wl_n[15] wl[16] wl_n[16] wl[17] wl_n[17] wl[18] wl_n[18] wl[19] wl_n[19] wl[20] wl_n[20] wl[21] wl_n[21] wl[22] wl_n[22] wl[23] wl_n[23] wl[24] wl_n[24] wl[25] wl_n[25] wl[26] wl_n[26] wl[27] wl_n[27] wl[28] wl_n[28] wl[29] wl_n[29] wl[30] wl_n[30] wl[31] wl_n[31] wl[32] wl_n[32] wl[33] wl_n[33] wl[34] wl_n[34] wl[35] wl_n[35] wl[36] wl_n[36] wl[37] wl_n[37] wl[38] wl_n[38] wl[39] wl_n[39] wl[40] wl_n[40] wl[41] wl_n[41] wl[42] wl_n[42] wl[43] wl_n[43] wl[44] wl_n[44] wl[45] wl_n[45] wl[46] wl_n[46] wl[47] wl_n[47] wl[48] wl_n[48] wl[49] wl_n[49] wl[50] wl_n[50] wl[51] wl_n[51] wl[52] wl_n[52] wl[53] wl_n[53] wl[54] wl_n[54] wl[55] wl_n[55] wl[56] wl_n[56] wl[57] wl_n[57] wl[58] wl_n[58] wl[59] wl_n[59] wl[60] wl_n[60] wl[61] wl_n[61] wl[62] wl_n[62] wl[63] wl_n[63] wl[64] wl_n[64] wl[65] wl_n[65] wl[66] wl_n[66] wl[67] wl_n[67] wl[68] wl_n[68] wl[69] wl_n[69] wl[70] wl_n[70] wl[71] wl_n[71] wl[72] wl_n[72] wl[73] wl_n[73] wl[74] wl_n[74] wl[75] wl_n[75] wl[76] wl_n[76] wl[77] wl_n[77] wl[78] wl_n[78] wl[79] wl_n[79] wl[80] wl_n[80] wl[81] wl_n[81] wl[82] wl_n[82] wl[83] wl_n[83] wl[84] wl_n[84] wl[85] wl_n[85] wl[86] wl_n[86] wl[87] wl_n[87] wl[88] wl_n[88] wl[89] wl_n[89] wl[90] wl_n[90] wl[91] wl_n[91] wl[92] wl_n[92] wl[93] wl_n[93] wl[94] wl_n[94] wl[95] wl_n[95] wl[96] wl_n[96] wl[97] wl_n[97] wl[98] wl_n[98] wl[99] wl_n[99] wl[100] wl_n[100] wl[101] wl_n[101] wl[102] wl_n[102] wl[103] wl_n[103] wl[104] wl_n[104] wl[105] wl_n[105] wl[106] wl_n[106] wl[107] wl_n[107] wl[108] wl_n[108] wl[109] wl_n[109] wl[110] wl_n[110] wl[111] wl_n[111] wl[112] wl_n[112] wl[113] wl_n[113] wl[114] wl_n[114] wl[115] wl_n[115] wl[116] wl_n[116] wl[117] wl_n[117] wl[118] wl_n[118] wl[119] wl_n[119] wl[120] wl_n[120] wl[121] wl_n[121] wl[122] wl_n[122] wl[123] wl_n[123] wl[124] wl_n[124] wl[125] wl_n[125] wl[126] wl_n[126] wl[127] wl_n[127]
Xdriver[0] vss vdd wl_n[0] wl[0] SPDICEWLDriver_N26L400WP26L800W
Xdriver[1] vss vdd wl_n[1] wl[1] SPDICEWLDriver_N26L400WP26L800W
Xdriver[2] vss vdd wl_n[2] wl[2] SPDICEWLDriver_N26L400WP26L800W
Xdriver[3] vss vdd wl_n[3] wl[3] SPDICEWLDriver_N26L400WP26L800W
Xdriver[4] vss vdd wl_n[4] wl[4] SPDICEWLDriver_N26L400WP26L800W
Xdriver[5] vss vdd wl_n[5] wl[5] SPDICEWLDriver_N26L400WP26L800W
Xdriver[6] vss vdd wl_n[6] wl[6] SPDICEWLDriver_N26L400WP26L800W
Xdriver[7] vss vdd wl_n[7] wl[7] SPDICEWLDriver_N26L400WP26L800W
Xdriver[8] vss vdd wl_n[8] wl[8] SPDICEWLDriver_N26L400WP26L800W
Xdriver[9] vss vdd wl_n[9] wl[9] SPDICEWLDriver_N26L400WP26L800W
Xdriver[10] vss vdd wl_n[10] wl[10] SPDICEWLDriver_N26L400WP26L800W
Xdriver[11] vss vdd wl_n[11] wl[11] SPDICEWLDriver_N26L400WP26L800W
Xdriver[12] vss vdd wl_n[12] wl[12] SPDICEWLDriver_N26L400WP26L800W
Xdriver[13] vss vdd wl_n[13] wl[13] SPDICEWLDriver_N26L400WP26L800W
Xdriver[14] vss vdd wl_n[14] wl[14] SPDICEWLDriver_N26L400WP26L800W
Xdriver[15] vss vdd wl_n[15] wl[15] SPDICEWLDriver_N26L400WP26L800W
Xdriver[16] vss vdd wl_n[16] wl[16] SPDICEWLDriver_N26L400WP26L800W
Xdriver[17] vss vdd wl_n[17] wl[17] SPDICEWLDriver_N26L400WP26L800W
Xdriver[18] vss vdd wl_n[18] wl[18] SPDICEWLDriver_N26L400WP26L800W
Xdriver[19] vss vdd wl_n[19] wl[19] SPDICEWLDriver_N26L400WP26L800W
Xdriver[20] vss vdd wl_n[20] wl[20] SPDICEWLDriver_N26L400WP26L800W
Xdriver[21] vss vdd wl_n[21] wl[21] SPDICEWLDriver_N26L400WP26L800W
Xdriver[22] vss vdd wl_n[22] wl[22] SPDICEWLDriver_N26L400WP26L800W
Xdriver[23] vss vdd wl_n[23] wl[23] SPDICEWLDriver_N26L400WP26L800W
Xdriver[24] vss vdd wl_n[24] wl[24] SPDICEWLDriver_N26L400WP26L800W
Xdriver[25] vss vdd wl_n[25] wl[25] SPDICEWLDriver_N26L400WP26L800W
Xdriver[26] vss vdd wl_n[26] wl[26] SPDICEWLDriver_N26L400WP26L800W
Xdriver[27] vss vdd wl_n[27] wl[27] SPDICEWLDriver_N26L400WP26L800W
Xdriver[28] vss vdd wl_n[28] wl[28] SPDICEWLDriver_N26L400WP26L800W
Xdriver[29] vss vdd wl_n[29] wl[29] SPDICEWLDriver_N26L400WP26L800W
Xdriver[30] vss vdd wl_n[30] wl[30] SPDICEWLDriver_N26L400WP26L800W
Xdriver[31] vss vdd wl_n[31] wl[31] SPDICEWLDriver_N26L400WP26L800W
Xdriver[32] vss vdd wl_n[32] wl[32] SPDICEWLDriver_N26L400WP26L800W
Xdriver[33] vss vdd wl_n[33] wl[33] SPDICEWLDriver_N26L400WP26L800W
Xdriver[34] vss vdd wl_n[34] wl[34] SPDICEWLDriver_N26L400WP26L800W
Xdriver[35] vss vdd wl_n[35] wl[35] SPDICEWLDriver_N26L400WP26L800W
Xdriver[36] vss vdd wl_n[36] wl[36] SPDICEWLDriver_N26L400WP26L800W
Xdriver[37] vss vdd wl_n[37] wl[37] SPDICEWLDriver_N26L400WP26L800W
Xdriver[38] vss vdd wl_n[38] wl[38] SPDICEWLDriver_N26L400WP26L800W
Xdriver[39] vss vdd wl_n[39] wl[39] SPDICEWLDriver_N26L400WP26L800W
Xdriver[40] vss vdd wl_n[40] wl[40] SPDICEWLDriver_N26L400WP26L800W
Xdriver[41] vss vdd wl_n[41] wl[41] SPDICEWLDriver_N26L400WP26L800W
Xdriver[42] vss vdd wl_n[42] wl[42] SPDICEWLDriver_N26L400WP26L800W
Xdriver[43] vss vdd wl_n[43] wl[43] SPDICEWLDriver_N26L400WP26L800W
Xdriver[44] vss vdd wl_n[44] wl[44] SPDICEWLDriver_N26L400WP26L800W
Xdriver[45] vss vdd wl_n[45] wl[45] SPDICEWLDriver_N26L400WP26L800W
Xdriver[46] vss vdd wl_n[46] wl[46] SPDICEWLDriver_N26L400WP26L800W
Xdriver[47] vss vdd wl_n[47] wl[47] SPDICEWLDriver_N26L400WP26L800W
Xdriver[48] vss vdd wl_n[48] wl[48] SPDICEWLDriver_N26L400WP26L800W
Xdriver[49] vss vdd wl_n[49] wl[49] SPDICEWLDriver_N26L400WP26L800W
Xdriver[50] vss vdd wl_n[50] wl[50] SPDICEWLDriver_N26L400WP26L800W
Xdriver[51] vss vdd wl_n[51] wl[51] SPDICEWLDriver_N26L400WP26L800W
Xdriver[52] vss vdd wl_n[52] wl[52] SPDICEWLDriver_N26L400WP26L800W
Xdriver[53] vss vdd wl_n[53] wl[53] SPDICEWLDriver_N26L400WP26L800W
Xdriver[54] vss vdd wl_n[54] wl[54] SPDICEWLDriver_N26L400WP26L800W
Xdriver[55] vss vdd wl_n[55] wl[55] SPDICEWLDriver_N26L400WP26L800W
Xdriver[56] vss vdd wl_n[56] wl[56] SPDICEWLDriver_N26L400WP26L800W
Xdriver[57] vss vdd wl_n[57] wl[57] SPDICEWLDriver_N26L400WP26L800W
Xdriver[58] vss vdd wl_n[58] wl[58] SPDICEWLDriver_N26L400WP26L800W
Xdriver[59] vss vdd wl_n[59] wl[59] SPDICEWLDriver_N26L400WP26L800W
Xdriver[60] vss vdd wl_n[60] wl[60] SPDICEWLDriver_N26L400WP26L800W
Xdriver[61] vss vdd wl_n[61] wl[61] SPDICEWLDriver_N26L400WP26L800W
Xdriver[62] vss vdd wl_n[62] wl[62] SPDICEWLDriver_N26L400WP26L800W
Xdriver[63] vss vdd wl_n[63] wl[63] SPDICEWLDriver_N26L400WP26L800W
Xdriver[64] vss vdd wl_n[64] wl[64] SPDICEWLDriver_N26L400WP26L800W
Xdriver[65] vss vdd wl_n[65] wl[65] SPDICEWLDriver_N26L400WP26L800W
Xdriver[66] vss vdd wl_n[66] wl[66] SPDICEWLDriver_N26L400WP26L800W
Xdriver[67] vss vdd wl_n[67] wl[67] SPDICEWLDriver_N26L400WP26L800W
Xdriver[68] vss vdd wl_n[68] wl[68] SPDICEWLDriver_N26L400WP26L800W
Xdriver[69] vss vdd wl_n[69] wl[69] SPDICEWLDriver_N26L400WP26L800W
Xdriver[70] vss vdd wl_n[70] wl[70] SPDICEWLDriver_N26L400WP26L800W
Xdriver[71] vss vdd wl_n[71] wl[71] SPDICEWLDriver_N26L400WP26L800W
Xdriver[72] vss vdd wl_n[72] wl[72] SPDICEWLDriver_N26L400WP26L800W
Xdriver[73] vss vdd wl_n[73] wl[73] SPDICEWLDriver_N26L400WP26L800W
Xdriver[74] vss vdd wl_n[74] wl[74] SPDICEWLDriver_N26L400WP26L800W
Xdriver[75] vss vdd wl_n[75] wl[75] SPDICEWLDriver_N26L400WP26L800W
Xdriver[76] vss vdd wl_n[76] wl[76] SPDICEWLDriver_N26L400WP26L800W
Xdriver[77] vss vdd wl_n[77] wl[77] SPDICEWLDriver_N26L400WP26L800W
Xdriver[78] vss vdd wl_n[78] wl[78] SPDICEWLDriver_N26L400WP26L800W
Xdriver[79] vss vdd wl_n[79] wl[79] SPDICEWLDriver_N26L400WP26L800W
Xdriver[80] vss vdd wl_n[80] wl[80] SPDICEWLDriver_N26L400WP26L800W
Xdriver[81] vss vdd wl_n[81] wl[81] SPDICEWLDriver_N26L400WP26L800W
Xdriver[82] vss vdd wl_n[82] wl[82] SPDICEWLDriver_N26L400WP26L800W
Xdriver[83] vss vdd wl_n[83] wl[83] SPDICEWLDriver_N26L400WP26L800W
Xdriver[84] vss vdd wl_n[84] wl[84] SPDICEWLDriver_N26L400WP26L800W
Xdriver[85] vss vdd wl_n[85] wl[85] SPDICEWLDriver_N26L400WP26L800W
Xdriver[86] vss vdd wl_n[86] wl[86] SPDICEWLDriver_N26L400WP26L800W
Xdriver[87] vss vdd wl_n[87] wl[87] SPDICEWLDriver_N26L400WP26L800W
Xdriver[88] vss vdd wl_n[88] wl[88] SPDICEWLDriver_N26L400WP26L800W
Xdriver[89] vss vdd wl_n[89] wl[89] SPDICEWLDriver_N26L400WP26L800W
Xdriver[90] vss vdd wl_n[90] wl[90] SPDICEWLDriver_N26L400WP26L800W
Xdriver[91] vss vdd wl_n[91] wl[91] SPDICEWLDriver_N26L400WP26L800W
Xdriver[92] vss vdd wl_n[92] wl[92] SPDICEWLDriver_N26L400WP26L800W
Xdriver[93] vss vdd wl_n[93] wl[93] SPDICEWLDriver_N26L400WP26L800W
Xdriver[94] vss vdd wl_n[94] wl[94] SPDICEWLDriver_N26L400WP26L800W
Xdriver[95] vss vdd wl_n[95] wl[95] SPDICEWLDriver_N26L400WP26L800W
Xdriver[96] vss vdd wl_n[96] wl[96] SPDICEWLDriver_N26L400WP26L800W
Xdriver[97] vss vdd wl_n[97] wl[97] SPDICEWLDriver_N26L400WP26L800W
Xdriver[98] vss vdd wl_n[98] wl[98] SPDICEWLDriver_N26L400WP26L800W
Xdriver[99] vss vdd wl_n[99] wl[99] SPDICEWLDriver_N26L400WP26L800W
Xdriver[100] vss vdd wl_n[100] wl[100] SPDICEWLDriver_N26L400WP26L800W
Xdriver[101] vss vdd wl_n[101] wl[101] SPDICEWLDriver_N26L400WP26L800W
Xdriver[102] vss vdd wl_n[102] wl[102] SPDICEWLDriver_N26L400WP26L800W
Xdriver[103] vss vdd wl_n[103] wl[103] SPDICEWLDriver_N26L400WP26L800W
Xdriver[104] vss vdd wl_n[104] wl[104] SPDICEWLDriver_N26L400WP26L800W
Xdriver[105] vss vdd wl_n[105] wl[105] SPDICEWLDriver_N26L400WP26L800W
Xdriver[106] vss vdd wl_n[106] wl[106] SPDICEWLDriver_N26L400WP26L800W
Xdriver[107] vss vdd wl_n[107] wl[107] SPDICEWLDriver_N26L400WP26L800W
Xdriver[108] vss vdd wl_n[108] wl[108] SPDICEWLDriver_N26L400WP26L800W
Xdriver[109] vss vdd wl_n[109] wl[109] SPDICEWLDriver_N26L400WP26L800W
Xdriver[110] vss vdd wl_n[110] wl[110] SPDICEWLDriver_N26L400WP26L800W
Xdriver[111] vss vdd wl_n[111] wl[111] SPDICEWLDriver_N26L400WP26L800W
Xdriver[112] vss vdd wl_n[112] wl[112] SPDICEWLDriver_N26L400WP26L800W
Xdriver[113] vss vdd wl_n[113] wl[113] SPDICEWLDriver_N26L400WP26L800W
Xdriver[114] vss vdd wl_n[114] wl[114] SPDICEWLDriver_N26L400WP26L800W
Xdriver[115] vss vdd wl_n[115] wl[115] SPDICEWLDriver_N26L400WP26L800W
Xdriver[116] vss vdd wl_n[116] wl[116] SPDICEWLDriver_N26L400WP26L800W
Xdriver[117] vss vdd wl_n[117] wl[117] SPDICEWLDriver_N26L400WP26L800W
Xdriver[118] vss vdd wl_n[118] wl[118] SPDICEWLDriver_N26L400WP26L800W
Xdriver[119] vss vdd wl_n[119] wl[119] SPDICEWLDriver_N26L400WP26L800W
Xdriver[120] vss vdd wl_n[120] wl[120] SPDICEWLDriver_N26L400WP26L800W
Xdriver[121] vss vdd wl_n[121] wl[121] SPDICEWLDriver_N26L400WP26L800W
Xdriver[122] vss vdd wl_n[122] wl[122] SPDICEWLDriver_N26L400WP26L800W
Xdriver[123] vss vdd wl_n[123] wl[123] SPDICEWLDriver_N26L400WP26L800W
Xdriver[124] vss vdd wl_n[124] wl[124] SPDICEWLDriver_N26L400WP26L800W
Xdriver[125] vss vdd wl_n[125] wl[125] SPDICEWLDriver_N26L400WP26L800W
Xdriver[126] vss vdd wl_n[126] wl[126] SPDICEWLDriver_N26L400WP26L800W
Xdriver[127] vss vdd wl_n[127] wl[127] SPDICEWLDriver_N26L400WP26L800W
.ends SPDICEWLDriverCol_128RN26L400WP26L800W

.subckt SPDICENonOvlClock_4S11341D1R vss vdd clk firststage[0] firststage[1] firststage[2] firststage[3] firststage[4] secondstage[0] secondstage[1] secondstage[2] secondstage[3] secondstage[4]
Xclkinv vdd vss clk clk_n inv_x0
Xfirstnand2 vdd vss firststage[0] clk secondstage[4] nand2_x0
Xfirststage[0] vdd vss firststage[0] firststage[1] inv_x0
Xfirststage[1] vdd vss firststage[1] firststage[2] inv_x0
Xfirststage[2] vdd vss firststage[2] firststage[3] inv_x0
Xfirststage[3] vdd vss firststage[3] firststage[4] inv_x0
Xsecondnand2 vdd vss secondstage[0] clk_n firststage[4] nand2_x0
Xsecondstage[0] vdd vss secondstage[0] secondstage[1] inv_x0
Xsecondstage[1] vdd vss secondstage[1] secondstage[2] inv_x0
Xsecondstage[2] vdd vss secondstage[2] secondstage[3] inv_x0
Xsecondstage[3] vdd vss secondstage[3] secondstage[4] inv_x0
.ends SPDICENonOvlClock_4S11341D1R

.subckt SPDICEClockGen_4S11341D1R vss vdd clk wl_en decodeclk columnclk precharge_n we_en
Xnonovl vss vdd clk firststage[0] firststage[1] firststage[2] firstpulse firststage[4] secondstage[0] secondstage[1] secondstage[2] secondpulse secondstage[4] SPDICENonOvlClock_4S11341D1R
Xdecodeclkbuf vdd vss clk decodeclk buf_x1
Xcolumnclkbuf vdd vss clk columnclk buf_x1
Xprechargeinv vdd vss secondpulse precharge_n inv_x3
Xwlenbuf vdd vss firstpulse wl_en buf_x4
Xweenbuf vdd vss firstpulse we_en buf_x1
.ends SPDICEClockGen_4S11341D1R

.subckt SPDICEDirectColDec_A2B2R vss vdd clk a[0] a[1] line[0] line[1] line[2] line[3]
Xaff[0] vdd vss a[0] clk aint[0] SP6T1Dec_dff_x1
Xaff[1] vdd vss a[1] clk aint[1] SP6T1Dec_dff_x1
Xainv[0] vdd vss aint[0] aint_n[0] SP6T1Dec_inv_x1
Xainv[1] vdd vss aint[1] aint_n[1] SP6T1Dec_inv_x1
Xlinenand[0] vdd vss line_n[0] aint_n[0] aint_n[1] SP6T1Dec_nand2_x0
Xlinenand[1] vdd vss line_n[1] aint[0] aint_n[1] SP6T1Dec_nand2_x0
Xlinenand[2] vdd vss line_n[2] aint_n[0] aint[1] SP6T1Dec_nand2_x0
Xlinenand[3] vdd vss line_n[3] aint[0] aint[1] SP6T1Dec_nand2_x0
Xlineinv[0] vdd vss line_n[0] line[0] SP6T1Dec_inv_x2
Xlineinv[1] vdd vss line_n[1] line[1] SP6T1Dec_inv_x2
Xlineinv[2] vdd vss line_n[2] line[2] SP6T1Dec_inv_x2
Xlineinv[3] vdd vss line_n[3] line[3] SP6T1Dec_inv_x2
.ends SPDICEDirectColDec_A2B2R

.subckt SPDICERowPredecoders_A3B4B vss vdd clk a[0] a[1] a[2] a[3] a[4] a[5] a[6] pd[0][0] pd[0][1] pd[0][2] pd[0][3] pd[0][4] pd[0][5] pd[0][6] pd[0][7] page[0] page[1] page[2] page[3] page[4] page[5] page[6] page[7] page[8] page[9] page[10] page[11] page[12] page[13] page[14] page[15]
Xaff[0] vdd vss a[0] clk aint[0] SP6T1Dec_dff_x1
Xaff[1] vdd vss a[1] clk aint[1] SP6T1Dec_dff_x1
Xaff[2] vdd vss a[2] clk aint[2] SP6T1Dec_dff_x1
Xaff[3] vdd vss a[3] clk aint[3] SP6T1Dec_dff_x1
Xaff[4] vdd vss a[4] clk aint[4] SP6T1Dec_dff_x1
Xaff[5] vdd vss a[5] clk aint[5] SP6T1Dec_dff_x1
Xaff[6] vdd vss a[6] clk aint[6] SP6T1Dec_dff_x1
Xainv[0] vdd vss aint[0] aint_n[0] SP6T1Dec_inv_x1
Xainv[1] vdd vss aint[1] aint_n[1] SP6T1Dec_inv_x1
Xainv[2] vdd vss aint[2] aint_n[2] SP6T1Dec_inv_x1
Xainv[3] vdd vss aint[3] aint_n[3] SP6T1Dec_inv_x1
Xainv[4] vdd vss aint[4] aint_n[4] SP6T1Dec_inv_x1
Xainv[5] vdd vss aint[5] aint_n[5] SP6T1Dec_inv_x1
Xainv[6] vdd vss aint[6] aint_n[6] SP6T1Dec_inv_x1
Xpd[0]and[0] vdd vss pd[0][0] aint_n[0] aint_n[1] aint_n[2] SP6T1Dec_and3_x1
Xpd[0]and[1] vdd vss pd[0][1] aint[0] aint_n[1] aint_n[2] SP6T1Dec_and3_x1
Xpd[0]and[2] vdd vss pd[0][2] aint_n[0] aint[1] aint_n[2] SP6T1Dec_and3_x1
Xpd[0]and[3] vdd vss pd[0][3] aint[0] aint[1] aint_n[2] SP6T1Dec_and3_x1
Xpd[0]and[4] vdd vss pd[0][4] aint_n[0] aint_n[1] aint[2] SP6T1Dec_and3_x1
Xpd[0]and[5] vdd vss pd[0][5] aint[0] aint_n[1] aint[2] SP6T1Dec_and3_x1
Xpd[0]and[6] vdd vss pd[0][6] aint_n[0] aint[1] aint[2] SP6T1Dec_and3_x1
Xpd[0]and[7] vdd vss pd[0][7] aint[0] aint[1] aint[2] SP6T1Dec_and3_x1
Xpage_and[0] vdd vss page[0] aint_n[3] aint_n[4] aint_n[5] aint_n[6] SP6T1Dec_and4_x1
Xpage_and[1] vdd vss page[1] aint[3] aint_n[4] aint_n[5] aint_n[6] SP6T1Dec_and4_x1
Xpage_and[2] vdd vss page[2] aint_n[3] aint[4] aint_n[5] aint_n[6] SP6T1Dec_and4_x1
Xpage_and[3] vdd vss page[3] aint[3] aint[4] aint_n[5] aint_n[6] SP6T1Dec_and4_x1
Xpage_and[4] vdd vss page[4] aint_n[3] aint_n[4] aint[5] aint_n[6] SP6T1Dec_and4_x1
Xpage_and[5] vdd vss page[5] aint[3] aint_n[4] aint[5] aint_n[6] SP6T1Dec_and4_x1
Xpage_and[6] vdd vss page[6] aint_n[3] aint[4] aint[5] aint_n[6] SP6T1Dec_and4_x1
Xpage_and[7] vdd vss page[7] aint[3] aint[4] aint[5] aint_n[6] SP6T1Dec_and4_x1
Xpage_and[8] vdd vss page[8] aint_n[3] aint_n[4] aint_n[5] aint[6] SP6T1Dec_and4_x1
Xpage_and[9] vdd vss page[9] aint[3] aint_n[4] aint_n[5] aint[6] SP6T1Dec_and4_x1
Xpage_and[10] vdd vss page[10] aint_n[3] aint[4] aint_n[5] aint[6] SP6T1Dec_and4_x1
Xpage_and[11] vdd vss page[11] aint[3] aint[4] aint_n[5] aint[6] SP6T1Dec_and4_x1
Xpage_and[12] vdd vss page[12] aint_n[3] aint_n[4] aint[5] aint[6] SP6T1Dec_and4_x1
Xpage_and[13] vdd vss page[13] aint[3] aint_n[4] aint[5] aint[6] SP6T1Dec_and4_x1
Xpage_and[14] vdd vss page[14] aint_n[3] aint[4] aint[5] aint[6] SP6T1Dec_and4_x1
Xpage_and[15] vdd vss page[15] aint[3] aint[4] aint[5] aint[6] SP6T1Dec_and4_x1
Xtie[0] vdd vss SP6T1Dec_tie_diff_w4
Xtie[1] vdd vss SP6T1Dec_tie_diff_w4
Xtie[2] vdd vss SP6T1Dec_tie_diff_w4
Xtie[3] vdd vss SP6T1Dec_tie_diff_w4
Xtie[4] vdd vss SP6T1Dec_tie_diff_w4
Xtie[5] vdd vss SP6T1Dec_tie_diff_w4
Xtie[6] vdd vss SP6T1Dec_tie_diff_w4
Xtie[7] vdd vss SP6T1Dec_tie_diff_w4
Xtie[8] vdd vss SP6T1Dec_tie_diff_w4
Xtie[9] vdd vss SP6T1Dec_tie_diff_w4
Xtie[10] vdd vss SP6T1Dec_tie_diff_w4
Xtie[11] vdd vss SP6T1Dec_tie_diff_w4
Xtie[12] vdd vss SP6T1Dec_tie_diff_w4
Xtie[13] vdd vss SP6T1Dec_tie_diff_w4
Xtie[14] vdd vss SP6T1Dec_tie_diff_w4
Xtie[15] vdd vss SP6T1Dec_tie_diff_w4
Xtie[16] vdd vss SP6T1Dec_tie_diff_w4
Xtie[17] vdd vss SP6T1Dec_tie_diff_w4
Xtie[18] vdd vss SP6T1Dec_tie_diff_w4
Xtie[19] vdd vss SP6T1Dec_tie_diff_w4
Xtie[20] vdd vss SP6T1Dec_tie_diff_w4
Xtie[21] vdd vss SP6T1Dec_tie_diff_w4
Xtie[22] vdd vss SP6T1Dec_tie_diff_w4
Xtie[23] vdd vss SP6T1Dec_tie_diff_w4
Xtie[24] vdd vss SP6T1Dec_tie_diff_w4
Xtie[25] vdd vss SP6T1Dec_tie_diff_w4
Xtie[26] vdd vss SP6T1Dec_tie_diff_w4
Xtie[27] vdd vss SP6T1Dec_tie_diff_w4
Xtie[28] vdd vss SP6T1Dec_tie_diff_w4
Xtie[29] vdd vss SP6T1Dec_tie_diff_w4
Xtie[30] vdd vss SP6T1Dec_tie_diff_w4
Xtie[31] vdd vss SP6T1Dec_tie_diff_w4
Xtie[32] vdd vss SP6T1Dec_tie_diff_w4
Xtie[33] vdd vss SP6T1Dec_tie_diff_w4
Xtie[34] vdd vss SP6T1Dec_tie_diff_w4
Xtie[35] vdd vss SP6T1Dec_tie_diff_w4
Xtie[36] vdd vss SP6T1Dec_tie_diff_w4
Xtie[37] vdd vss SP6T1Dec_tie_diff_w4
Xtie[38] vdd vss SP6T1Dec_tie_diff_w4
Xtie[39] vdd vss SP6T1Dec_tie_diff_w4
Xtie[40] vdd vss SP6T1Dec_tie_diff_w4
Xtie[41] vdd vss SP6T1Dec_tie_diff_w4
Xtie[42] vdd vss SP6T1Dec_tie_diff_w4
Xtie[43] vdd vss SP6T1Dec_tie_diff_w4
Xtie[44] vdd vss SP6T1Dec_tie_diff_w4
Xtie[45] vdd vss SP6T1Dec_tie_diff_w4
Xtie[46] vdd vss SP6T1Dec_tie_diff_w4
Xtie[47] vdd vss SP6T1Dec_tie_diff_w4
Xtie[48] vdd vss SP6T1Dec_tie_diff_w4
Xtie[49] vdd vss SP6T1Dec_tie_diff_w4
Xtie[50] vdd vss SP6T1Dec_tie_diff_w4
Xtie[51] vdd vss SP6T1Dec_tie_diff_w4
Xtie[52] vdd vss SP6T1Dec_tie_diff_w4
Xtie[53] vdd vss SP6T1Dec_tie_diff_w4
Xtie[54] vdd vss SP6T1Dec_tie_diff_w4
Xtie[55] vdd vss SP6T1Dec_tie_diff_w4
Xtie[56] vdd vss SP6T1Dec_tie_diff_w4
Xtie[57] vdd vss SP6T1Dec_tie_diff_w4
Xtie[58] vdd vss SP6T1Dec_tie_diff_w4
Xtie[59] vdd vss SP6T1Dec_tie_diff_w4
Xtie[60] vdd vss SP6T1Dec_tie_diff_w4
Xtie[61] vdd vss SP6T1Dec_tie_diff_w4
Xtie[62] vdd vss SP6T1Dec_tie_diff_w4
Xtie[62] vdd vss SP6T1Dec_tie_diff_w4
Xtie[62] vdd vss SP6T1Dec_tie_diff_w4
Xtie[62] vdd vss SP6T1Dec_tie_diff_w4
Xtie[62] vdd vss SP6T1Dec_tie_diff_w4
Xtie[62] vdd vss SP6T1Dec_tie_diff_w4
Xtie[62] vdd vss SP6T1Dec_tie_diff_w4
Xtie[62] vdd vss SP6T1Dec_tie_diff_w4
Xtie[62] vdd vss SP6T1Dec_tie_diff_w4
Xtie[62] vdd vss SP6T1Dec_tie_diff_w4
Xtie[62] vdd vss SP6T1Dec_tie_diff_w4
Xtie[62] vdd vss SP6T1Dec_tie_diff_w4
Xtie[62] vdd vss SP6T1Dec_tie_diff_w4
Xtie[62] vdd vss SP6T1Dec_tie_diff_w4
Xtie[62] vdd vss SP6T1Dec_tie_diff_w4
Xtie[62] vdd vss SP6T1Dec_tie_diff_w4
Xtie[62] vdd vss SP6T1Dec_tie_diff_w4
Xtie[62] vdd vss SP6T1Dec_tie_diff_w4
Xtie[62] vdd vss SP6T1Dec_tie_diff_w4
Xtie[62] vdd vss SP6T1Dec_tie_diff_w4
Xtie[62] vdd vss SP6T1Dec_tie_diff_w4
Xtie[62] vdd vss SP6T1Dec_tie_diff_w4
Xtie[62] vdd vss SP6T1Dec_tie_diff_w4
Xtie[62] vdd vss SP6T1Dec_tie_diff_w4
Xtie[62] vdd vss SP6T1Dec_tie_diff_w4
Xtie[62] vdd vss SP6T1Dec_tie_diff_w4
Xtie[62] vdd vss SP6T1Dec_tie_diff_w4
Xtie[62] vdd vss SP6T1Dec_tie_diff_w4
Xtie[62] vdd vss SP6T1Dec_tie_diff_w4
Xtie[62] vdd vss SP6T1Dec_tie_diff_w4
Xtie[62] vdd vss SP6T1Dec_tie_diff_w4
Xtie[62] vdd vss SP6T1Dec_tie_diff_w4
Xtie[62] vdd vss SP6T1Dec_tie_diff_w4
Xtie[62] vdd vss SP6T1Dec_tie_diff_w4
Xtie[62] vdd vss SP6T1Dec_tie_diff_w4
Xtie[62] vdd vss SP6T1Dec_tie_diff_w4
Xtie[62] vdd vss SP6T1Dec_tie_diff_w4
Xtie[62] vdd vss SP6T1Dec_tie_diff_w4
Xtie[62] vdd vss SP6T1Dec_tie_diff_w4
Xtie[62] vdd vss SP6T1Dec_tie_diff_w4
Xtie[62] vdd vss SP6T1Dec_tie_diff_w4
Xtie[62] vdd vss SP6T1Dec_tie_diff_w4
Xtie[62] vdd vss SP6T1Dec_tie_diff_w4
Xtie[62] vdd vss SP6T1Dec_tie_diff_w4
Xtie[62] vdd vss SP6T1Dec_tie_diff_w4
Xtie[62] vdd vss SP6T1Dec_tie_diff_w4
Xtie[62] vdd vss SP6T1Dec_tie_diff_w4
Xtie[62] vdd vss SP6T1Dec_tie_diff_w4
Xtie[62] vdd vss SP6T1Dec_tie_diff_w4
Xtie[62] vdd vss SP6T1Dec_tie_diff_w4
Xtie[62] vdd vss SP6T1Dec_tie_diff_w4
Xtie[62] vdd vss SP6T1Dec_tie_diff_w4
Xtie[62] vdd vss SP6T1Dec_tie_diff_w4
Xtie[62] vdd vss SP6T1Dec_tie_diff_w4
Xtie[62] vdd vss SP6T1Dec_tie_diff_w4
Xtie[62] vdd vss SP6T1Dec_tie_diff_w4
Xtie[62] vdd vss SP6T1Dec_tie_diff_w4
Xtie[62] vdd vss SP6T1Dec_tie_diff_w4
Xtie[62] vdd vss SP6T1Dec_tie_diff_w4
.ends SPDICERowPredecoders_A3B4B

.subckt SPDICERowDecoderNand3 vss vdd pd[0] page wl_en wl_n
Xnmos[0] vss pd[0] int[0] vss sg13_lv_nmos l=1.3e-07 w=4.6e-07
Xnmos[1] int[0] page int[1] vss sg13_lv_nmos l=1.3e-07 w=4.6e-07
Xnmos[2] int[1] wl_en wl_n vss sg13_lv_nmos l=1.3e-07 w=4.6e-07
Xpmos[0] vdd pd[0] wl_n vdd sg13_lv_pmos l=1.3e-07 w=4.6e-07
Xpmos[1] wl_n page vdd vdd sg13_lv_pmos l=1.3e-07 w=4.6e-07
Xpmos[2] vdd wl_en wl_n vdd sg13_lv_pmos l=1.3e-07 w=4.6e-07
.ends SPDICERowDecoderNand3

.subckt SPDICERowDecPage_PD3B4BSH vss vdd pd[0][0] wl_n[0] pd[0][1] wl_n[1] pd[0][2] wl_n[2] pd[0][3] wl_n[3] pd[0][4] wl_n[4] pd[0][5] wl_n[5] pd[0][6] wl_n[6] pd[0][7] wl_n[7] page wl_en
Xnand3[0] vss vdd pd[0][0] page wl_en wl_n[0] SPDICERowDecoderNand3
Xnand3[1] vss vdd pd[0][1] page wl_en wl_n[1] SPDICERowDecoderNand3
Xnand3[2] vss vdd pd[0][2] page wl_en wl_n[2] SPDICERowDecoderNand3
Xnand3[3] vss vdd pd[0][3] page wl_en wl_n[3] SPDICERowDecoderNand3
Xnand3[4] vss vdd pd[0][4] page wl_en wl_n[4] SPDICERowDecoderNand3
Xnand3[5] vss vdd pd[0][5] page wl_en wl_n[5] SPDICERowDecoderNand3
Xnand3[6] vss vdd pd[0][6] page wl_en wl_n[6] SPDICERowDecoderNand3
Xnand3[7] vss vdd pd[0][7] page wl_en wl_n[7] SPDICERowDecoderNand3
.ends SPDICERowDecPage_PD3B4BSH

.subckt SPDICERowDec_PD3B4B_PAG3B4B1 vss vdd a[0] a[1] a[2] a[3] a[4] a[5] a[6] clk wl_en wl_n[0] wl_n[1] wl_n[2] wl_n[3] wl_n[4] wl_n[5] wl_n[6] wl_n[7] wl_n[8] wl_n[9] wl_n[10] wl_n[11] wl_n[12] wl_n[13] wl_n[14] wl_n[15] wl_n[16] wl_n[17] wl_n[18] wl_n[19] wl_n[20] wl_n[21] wl_n[22] wl_n[23] wl_n[24] wl_n[25] wl_n[26] wl_n[27] wl_n[28] wl_n[29] wl_n[30] wl_n[31] wl_n[32] wl_n[33] wl_n[34] wl_n[35] wl_n[36] wl_n[37] wl_n[38] wl_n[39] wl_n[40] wl_n[41] wl_n[42] wl_n[43] wl_n[44] wl_n[45] wl_n[46] wl_n[47] wl_n[48] wl_n[49] wl_n[50] wl_n[51] wl_n[52] wl_n[53] wl_n[54] wl_n[55] wl_n[56] wl_n[57] wl_n[58] wl_n[59] wl_n[60] wl_n[61] wl_n[62] wl_n[63] wl_n[64] wl_n[65] wl_n[66] wl_n[67] wl_n[68] wl_n[69] wl_n[70] wl_n[71] wl_n[72] wl_n[73] wl_n[74] wl_n[75] wl_n[76] wl_n[77] wl_n[78] wl_n[79] wl_n[80] wl_n[81] wl_n[82] wl_n[83] wl_n[84] wl_n[85] wl_n[86] wl_n[87] wl_n[88] wl_n[89] wl_n[90] wl_n[91] wl_n[92] wl_n[93] wl_n[94] wl_n[95] wl_n[96] wl_n[97] wl_n[98] wl_n[99] wl_n[100] wl_n[101] wl_n[102] wl_n[103] wl_n[104] wl_n[105] wl_n[106] wl_n[107] wl_n[108] wl_n[109] wl_n[110] wl_n[111] wl_n[112] wl_n[113] wl_n[114] wl_n[115] wl_n[116] wl_n[117] wl_n[118] wl_n[119] wl_n[120] wl_n[121] wl_n[122] wl_n[123] wl_n[124] wl_n[125] wl_n[126] wl_n[127]
Xpredec vss vdd clk a[0] a[1] a[2] a[3] a[4] a[5] a[6] pd[0][0] pd[0][1] pd[0][2] pd[0][3] pd[0][4] pd[0][5] pd[0][6] pd[0][7] page[0] page[1] page[2] page[3] page[4] page[5] page[6] page[7] page[8] page[9] page[10] page[11] page[12] page[13] page[14] page[15] SPDICERowPredecoders_A3B4B
Xpage[0] vss vdd pd[0][0] wl_n[0] pd[0][1] wl_n[1] pd[0][2] wl_n[2] pd[0][3] wl_n[3] pd[0][4] wl_n[4] pd[0][5] wl_n[5] pd[0][6] wl_n[6] pd[0][7] wl_n[7] page[0] wl_en SPDICERowDecPage_PD3B4BSH
Xpage[1] vss vdd pd[0][0] wl_n[8] pd[0][1] wl_n[9] pd[0][2] wl_n[10] pd[0][3] wl_n[11] pd[0][4] wl_n[12] pd[0][5] wl_n[13] pd[0][6] wl_n[14] pd[0][7] wl_n[15] page[1] wl_en SPDICERowDecPage_PD3B4BSH
Xpage[2] vss vdd pd[0][0] wl_n[16] pd[0][1] wl_n[17] pd[0][2] wl_n[18] pd[0][3] wl_n[19] pd[0][4] wl_n[20] pd[0][5] wl_n[21] pd[0][6] wl_n[22] pd[0][7] wl_n[23] page[2] wl_en SPDICERowDecPage_PD3B4BSH
Xpage[3] vss vdd pd[0][0] wl_n[24] pd[0][1] wl_n[25] pd[0][2] wl_n[26] pd[0][3] wl_n[27] pd[0][4] wl_n[28] pd[0][5] wl_n[29] pd[0][6] wl_n[30] pd[0][7] wl_n[31] page[3] wl_en SPDICERowDecPage_PD3B4BSH
Xpage[4] vss vdd pd[0][0] wl_n[32] pd[0][1] wl_n[33] pd[0][2] wl_n[34] pd[0][3] wl_n[35] pd[0][4] wl_n[36] pd[0][5] wl_n[37] pd[0][6] wl_n[38] pd[0][7] wl_n[39] page[4] wl_en SPDICERowDecPage_PD3B4BSH
Xpage[5] vss vdd pd[0][0] wl_n[40] pd[0][1] wl_n[41] pd[0][2] wl_n[42] pd[0][3] wl_n[43] pd[0][4] wl_n[44] pd[0][5] wl_n[45] pd[0][6] wl_n[46] pd[0][7] wl_n[47] page[5] wl_en SPDICERowDecPage_PD3B4BSH
Xpage[6] vss vdd pd[0][0] wl_n[48] pd[0][1] wl_n[49] pd[0][2] wl_n[50] pd[0][3] wl_n[51] pd[0][4] wl_n[52] pd[0][5] wl_n[53] pd[0][6] wl_n[54] pd[0][7] wl_n[55] page[6] wl_en SPDICERowDecPage_PD3B4BSH
Xpage[7] vss vdd pd[0][0] wl_n[56] pd[0][1] wl_n[57] pd[0][2] wl_n[58] pd[0][3] wl_n[59] pd[0][4] wl_n[60] pd[0][5] wl_n[61] pd[0][6] wl_n[62] pd[0][7] wl_n[63] page[7] wl_en SPDICERowDecPage_PD3B4BSH
Xpage[8] vss vdd pd[0][0] wl_n[64] pd[0][1] wl_n[65] pd[0][2] wl_n[66] pd[0][3] wl_n[67] pd[0][4] wl_n[68] pd[0][5] wl_n[69] pd[0][6] wl_n[70] pd[0][7] wl_n[71] page[8] wl_en SPDICERowDecPage_PD3B4BSH
Xpage[9] vss vdd pd[0][0] wl_n[72] pd[0][1] wl_n[73] pd[0][2] wl_n[74] pd[0][3] wl_n[75] pd[0][4] wl_n[76] pd[0][5] wl_n[77] pd[0][6] wl_n[78] pd[0][7] wl_n[79] page[9] wl_en SPDICERowDecPage_PD3B4BSH
Xpage[10] vss vdd pd[0][0] wl_n[80] pd[0][1] wl_n[81] pd[0][2] wl_n[82] pd[0][3] wl_n[83] pd[0][4] wl_n[84] pd[0][5] wl_n[85] pd[0][6] wl_n[86] pd[0][7] wl_n[87] page[10] wl_en SPDICERowDecPage_PD3B4BSH
Xpage[11] vss vdd pd[0][0] wl_n[88] pd[0][1] wl_n[89] pd[0][2] wl_n[90] pd[0][3] wl_n[91] pd[0][4] wl_n[92] pd[0][5] wl_n[93] pd[0][6] wl_n[94] pd[0][7] wl_n[95] page[11] wl_en SPDICERowDecPage_PD3B4BSH
Xpage[12] vss vdd pd[0][0] wl_n[96] pd[0][1] wl_n[97] pd[0][2] wl_n[98] pd[0][3] wl_n[99] pd[0][4] wl_n[100] pd[0][5] wl_n[101] pd[0][6] wl_n[102] pd[0][7] wl_n[103] page[12] wl_en SPDICERowDecPage_PD3B4BSH
Xpage[13] vss vdd pd[0][0] wl_n[104] pd[0][1] wl_n[105] pd[0][2] wl_n[106] pd[0][3] wl_n[107] pd[0][4] wl_n[108] pd[0][5] wl_n[109] pd[0][6] wl_n[110] pd[0][7] wl_n[111] page[13] wl_en SPDICERowDecPage_PD3B4BSH
Xpage[14] vss vdd pd[0][0] wl_n[112] pd[0][1] wl_n[113] pd[0][2] wl_n[114] pd[0][3] wl_n[115] pd[0][4] wl_n[116] pd[0][5] wl_n[117] pd[0][6] wl_n[118] pd[0][7] wl_n[119] page[14] wl_en SPDICERowDecPage_PD3B4BSH
Xpage[15] vss vdd pd[0][0] wl_n[120] pd[0][1] wl_n[121] pd[0][2] wl_n[122] pd[0][3] wl_n[123] pd[0][4] wl_n[124] pd[0][5] wl_n[125] pd[0][6] wl_n[126] pd[0][7] wl_n[127] page[15] wl_en SPDICERowDecPage_PD3B4BSH
.ends SPDICERowDec_PD3B4B_PAG3B4B1

.subckt SPDICERowPeriph_PD3B4B_LD2B2R vss vdd a[0] a[1] a[2] a[3] a[4] a[5] a[6] a[7] a[8] wl_n[0] wl_n[1] wl_n[2] wl_n[3] wl_n[4] wl_n[5] wl_n[6] wl_n[7] wl_n[8] wl_n[9] wl_n[10] wl_n[11] wl_n[12] wl_n[13] wl_n[14] wl_n[15] wl_n[16] wl_n[17] wl_n[18] wl_n[19] wl_n[20] wl_n[21] wl_n[22] wl_n[23] wl_n[24] wl_n[25] wl_n[26] wl_n[27] wl_n[28] wl_n[29] wl_n[30] wl_n[31] wl_n[32] wl_n[33] wl_n[34] wl_n[35] wl_n[36] wl_n[37] wl_n[38] wl_n[39] wl_n[40] wl_n[41] wl_n[42] wl_n[43] wl_n[44] wl_n[45] wl_n[46] wl_n[47] wl_n[48] wl_n[49] wl_n[50] wl_n[51] wl_n[52] wl_n[53] wl_n[54] wl_n[55] wl_n[56] wl_n[57] wl_n[58] wl_n[59] wl_n[60] wl_n[61] wl_n[62] wl_n[63] wl_n[64] wl_n[65] wl_n[66] wl_n[67] wl_n[68] wl_n[69] wl_n[70] wl_n[71] wl_n[72] wl_n[73] wl_n[74] wl_n[75] wl_n[76] wl_n[77] wl_n[78] wl_n[79] wl_n[80] wl_n[81] wl_n[82] wl_n[83] wl_n[84] wl_n[85] wl_n[86] wl_n[87] wl_n[88] wl_n[89] wl_n[90] wl_n[91] wl_n[92] wl_n[93] wl_n[94] wl_n[95] wl_n[96] wl_n[97] wl_n[98] wl_n[99] wl_n[100] wl_n[101] wl_n[102] wl_n[103] wl_n[104] wl_n[105] wl_n[106] wl_n[107] wl_n[108] wl_n[109] wl_n[110] wl_n[111] wl_n[112] wl_n[113] wl_n[114] wl_n[115] wl_n[116] wl_n[117] wl_n[118] wl_n[119] wl_n[120] wl_n[121] wl_n[122] wl_n[123] wl_n[124] wl_n[125] wl_n[126] wl_n[127] decodeclk wl_en mux[0] mux[1] mux[2] mux[3]
Xcoldec vss vdd decodeclk a[0] a[1] mux[0] mux[1] mux[2] mux[3] SPDICEDirectColDec_A2B2R
Xrowdec vss vdd a[2] a[3] a[4] a[5] a[6] a[7] a[8] decodeclk wl_en wl_n[0] wl_n[1] wl_n[2] wl_n[3] wl_n[4] wl_n[5] wl_n[6] wl_n[7] wl_n[8] wl_n[9] wl_n[10] wl_n[11] wl_n[12] wl_n[13] wl_n[14] wl_n[15] wl_n[16] wl_n[17] wl_n[18] wl_n[19] wl_n[20] wl_n[21] wl_n[22] wl_n[23] wl_n[24] wl_n[25] wl_n[26] wl_n[27] wl_n[28] wl_n[29] wl_n[30] wl_n[31] wl_n[32] wl_n[33] wl_n[34] wl_n[35] wl_n[36] wl_n[37] wl_n[38] wl_n[39] wl_n[40] wl_n[41] wl_n[42] wl_n[43] wl_n[44] wl_n[45] wl_n[46] wl_n[47] wl_n[48] wl_n[49] wl_n[50] wl_n[51] wl_n[52] wl_n[53] wl_n[54] wl_n[55] wl_n[56] wl_n[57] wl_n[58] wl_n[59] wl_n[60] wl_n[61] wl_n[62] wl_n[63] wl_n[64] wl_n[65] wl_n[66] wl_n[67] wl_n[68] wl_n[69] wl_n[70] wl_n[71] wl_n[72] wl_n[73] wl_n[74] wl_n[75] wl_n[76] wl_n[77] wl_n[78] wl_n[79] wl_n[80] wl_n[81] wl_n[82] wl_n[83] wl_n[84] wl_n[85] wl_n[86] wl_n[87] wl_n[88] wl_n[89] wl_n[90] wl_n[91] wl_n[92] wl_n[93] wl_n[94] wl_n[95] wl_n[96] wl_n[97] wl_n[98] wl_n[99] wl_n[100] wl_n[101] wl_n[102] wl_n[103] wl_n[104] wl_n[105] wl_n[106] wl_n[107] wl_n[108] wl_n[109] wl_n[110] wl_n[111] wl_n[112] wl_n[113] wl_n[114] wl_n[115] wl_n[116] wl_n[117] wl_n[118] wl_n[119] wl_n[120] wl_n[121] wl_n[122] wl_n[123] wl_n[124] wl_n[125] wl_n[126] wl_n[127] SPDICERowDec_PD3B4B_PAG3B4B1
.ends SPDICERowPeriph_PD3B4B_LD2B2R

.subckt SPDICEBlock_512x32_4we_C2B_R3B4B clk a[0] a[1] a[2] a[3] a[4] a[5] a[6] a[7] a[8] vss vdd q[0] q[1] q[2] q[3] q[4] q[5] q[6] q[7] q[8] q[9] q[10] q[11] q[12] q[13] q[14] q[15] q[16] q[17] q[18] q[19] q[20] q[21] q[22] q[23] q[24] q[25] q[26] q[27] q[28] q[29] q[30] q[31] d[0] d[1] d[2] d[3] d[4] d[5] d[6] d[7] d[8] d[9] d[10] d[11] d[12] d[13] d[14] d[15] d[16] d[17] d[18] d[19] d[20] d[21] d[22] d[23] d[24] d[25] d[26] d[27] d[28] d[29] d[30] d[31] we[0] we[1] we[2] we[3]
Xcolumnblock vss vdd columnclk precharge_n we_en wl[0] wl[1] wl[2] wl[3] wl[4] wl[5] wl[6] wl[7] wl[8] wl[9] wl[10] wl[11] wl[12] wl[13] wl[14] wl[15] wl[16] wl[17] wl[18] wl[19] wl[20] wl[21] wl[22] wl[23] wl[24] wl[25] wl[26] wl[27] wl[28] wl[29] wl[30] wl[31] wl[32] wl[33] wl[34] wl[35] wl[36] wl[37] wl[38] wl[39] wl[40] wl[41] wl[42] wl[43] wl[44] wl[45] wl[46] wl[47] wl[48] wl[49] wl[50] wl[51] wl[52] wl[53] wl[54] wl[55] wl[56] wl[57] wl[58] wl[59] wl[60] wl[61] wl[62] wl[63] wl[64] wl[65] wl[66] wl[67] wl[68] wl[69] wl[70] wl[71] wl[72] wl[73] wl[74] wl[75] wl[76] wl[77] wl[78] wl[79] wl[80] wl[81] wl[82] wl[83] wl[84] wl[85] wl[86] wl[87] wl[88] wl[89] wl[90] wl[91] wl[92] wl[93] wl[94] wl[95] wl[96] wl[97] wl[98] wl[99] wl[100] wl[101] wl[102] wl[103] wl[104] wl[105] wl[106] wl[107] wl[108] wl[109] wl[110] wl[111] wl[112] wl[113] wl[114] wl[115] wl[116] wl[117] wl[118] wl[119] wl[120] wl[121] wl[122] wl[123] wl[124] wl[125] wl[126] wl[127] mux[0] mux[1] mux[2] mux[3] we[0] q[0] d[0] q[1] d[1] q[2] d[2] q[3] d[3] q[4] d[4] q[5] d[5] q[6] d[6] q[7] d[7] we[1] q[8] d[8] q[9] d[9] q[10] d[10] q[11] d[11] q[12] d[12] q[13] d[13] q[14] d[14] q[15] d[15] we[2] q[16] d[16] q[17] d[17] q[18] d[18] q[19] d[19] q[20] d[20] q[21] d[21] q[22] d[22] q[23] d[23] we[3] q[24] d[24] q[25] d[25] q[26] d[26] q[27] d[27] q[28] d[28] q[29] d[29] q[30] d[30] q[31] d[31] SPDICEColumnBlock_COL128R_CP8B_CM4MN26L580W1R_PC26L100W_4WE
Xwldrivercol vss vdd wl[0] wl_n[0] wl[1] wl_n[1] wl[2] wl_n[2] wl[3] wl_n[3] wl[4] wl_n[4] wl[5] wl_n[5] wl[6] wl_n[6] wl[7] wl_n[7] wl[8] wl_n[8] wl[9] wl_n[9] wl[10] wl_n[10] wl[11] wl_n[11] wl[12] wl_n[12] wl[13] wl_n[13] wl[14] wl_n[14] wl[15] wl_n[15] wl[16] wl_n[16] wl[17] wl_n[17] wl[18] wl_n[18] wl[19] wl_n[19] wl[20] wl_n[20] wl[21] wl_n[21] wl[22] wl_n[22] wl[23] wl_n[23] wl[24] wl_n[24] wl[25] wl_n[25] wl[26] wl_n[26] wl[27] wl_n[27] wl[28] wl_n[28] wl[29] wl_n[29] wl[30] wl_n[30] wl[31] wl_n[31] wl[32] wl_n[32] wl[33] wl_n[33] wl[34] wl_n[34] wl[35] wl_n[35] wl[36] wl_n[36] wl[37] wl_n[37] wl[38] wl_n[38] wl[39] wl_n[39] wl[40] wl_n[40] wl[41] wl_n[41] wl[42] wl_n[42] wl[43] wl_n[43] wl[44] wl_n[44] wl[45] wl_n[45] wl[46] wl_n[46] wl[47] wl_n[47] wl[48] wl_n[48] wl[49] wl_n[49] wl[50] wl_n[50] wl[51] wl_n[51] wl[52] wl_n[52] wl[53] wl_n[53] wl[54] wl_n[54] wl[55] wl_n[55] wl[56] wl_n[56] wl[57] wl_n[57] wl[58] wl_n[58] wl[59] wl_n[59] wl[60] wl_n[60] wl[61] wl_n[61] wl[62] wl_n[62] wl[63] wl_n[63] wl[64] wl_n[64] wl[65] wl_n[65] wl[66] wl_n[66] wl[67] wl_n[67] wl[68] wl_n[68] wl[69] wl_n[69] wl[70] wl_n[70] wl[71] wl_n[71] wl[72] wl_n[72] wl[73] wl_n[73] wl[74] wl_n[74] wl[75] wl_n[75] wl[76] wl_n[76] wl[77] wl_n[77] wl[78] wl_n[78] wl[79] wl_n[79] wl[80] wl_n[80] wl[81] wl_n[81] wl[82] wl_n[82] wl[83] wl_n[83] wl[84] wl_n[84] wl[85] wl_n[85] wl[86] wl_n[86] wl[87] wl_n[87] wl[88] wl_n[88] wl[89] wl_n[89] wl[90] wl_n[90] wl[91] wl_n[91] wl[92] wl_n[92] wl[93] wl_n[93] wl[94] wl_n[94] wl[95] wl_n[95] wl[96] wl_n[96] wl[97] wl_n[97] wl[98] wl_n[98] wl[99] wl_n[99] wl[100] wl_n[100] wl[101] wl_n[101] wl[102] wl_n[102] wl[103] wl_n[103] wl[104] wl_n[104] wl[105] wl_n[105] wl[106] wl_n[106] wl[107] wl_n[107] wl[108] wl_n[108] wl[109] wl_n[109] wl[110] wl_n[110] wl[111] wl_n[111] wl[112] wl_n[112] wl[113] wl_n[113] wl[114] wl_n[114] wl[115] wl_n[115] wl[116] wl_n[116] wl[117] wl_n[117] wl[118] wl_n[118] wl[119] wl_n[119] wl[120] wl_n[120] wl[121] wl_n[121] wl[122] wl_n[122] wl[123] wl_n[123] wl[124] wl_n[124] wl[125] wl_n[125] wl[126] wl_n[126] wl[127] wl_n[127] SPDICEWLDriverCol_128RN26L400WP26L800W
Xclkgen vss vdd clk wl_en decodeclk columnclk precharge_n we_en SPDICEClockGen_4S11341D1R
Xrowperiph vss vdd a[0] a[1] a[2] a[3] a[4] a[5] a[6] a[7] a[8] wl_n[0] wl_n[1] wl_n[2] wl_n[3] wl_n[4] wl_n[5] wl_n[6] wl_n[7] wl_n[8] wl_n[9] wl_n[10] wl_n[11] wl_n[12] wl_n[13] wl_n[14] wl_n[15] wl_n[16] wl_n[17] wl_n[18] wl_n[19] wl_n[20] wl_n[21] wl_n[22] wl_n[23] wl_n[24] wl_n[25] wl_n[26] wl_n[27] wl_n[28] wl_n[29] wl_n[30] wl_n[31] wl_n[32] wl_n[33] wl_n[34] wl_n[35] wl_n[36] wl_n[37] wl_n[38] wl_n[39] wl_n[40] wl_n[41] wl_n[42] wl_n[43] wl_n[44] wl_n[45] wl_n[46] wl_n[47] wl_n[48] wl_n[49] wl_n[50] wl_n[51] wl_n[52] wl_n[53] wl_n[54] wl_n[55] wl_n[56] wl_n[57] wl_n[58] wl_n[59] wl_n[60] wl_n[61] wl_n[62] wl_n[63] wl_n[64] wl_n[65] wl_n[66] wl_n[67] wl_n[68] wl_n[69] wl_n[70] wl_n[71] wl_n[72] wl_n[73] wl_n[74] wl_n[75] wl_n[76] wl_n[77] wl_n[78] wl_n[79] wl_n[80] wl_n[81] wl_n[82] wl_n[83] wl_n[84] wl_n[85] wl_n[86] wl_n[87] wl_n[88] wl_n[89] wl_n[90] wl_n[91] wl_n[92] wl_n[93] wl_n[94] wl_n[95] wl_n[96] wl_n[97] wl_n[98] wl_n[99] wl_n[100] wl_n[101] wl_n[102] wl_n[103] wl_n[104] wl_n[105] wl_n[106] wl_n[107] wl_n[108] wl_n[109] wl_n[110] wl_n[111] wl_n[112] wl_n[113] wl_n[114] wl_n[115] wl_n[116] wl_n[117] wl_n[118] wl_n[119] wl_n[120] wl_n[121] wl_n[122] wl_n[123] wl_n[124] wl_n[125] wl_n[126] wl_n[127] decodeclk wl_en mux[0] mux[1] mux[2] mux[3] SPDICERowPeriph_PD3B4B_LD2B2R
.ends SPDICEBlock_512x32_4we_C2B_R3B4B

.subckt SPDICETimingIn_9SF vss vdd sr_in sr_out sr_shift sr_latch i[8] i[7] i[6] i[5] i[4] i[3] i[2] i[1] i[0]
Xshiftff[8] vdd vss sr_in sr_shift i_s[8] dff_x1
Xshiftff[7] vdd vss i_s[8] sr_shift i_s[7] dff_x1
Xshiftff[6] vdd vss i_s[7] sr_shift i_s[6] dff_x1
Xshiftff[5] vdd vss i_s[6] sr_shift i_s[5] dff_x1
Xshiftff[4] vdd vss i_s[5] sr_shift i_s[4] dff_x1
Xshiftff[3] vdd vss i_s[4] sr_shift i_s[3] dff_x1
Xshiftff[2] vdd vss i_s[3] sr_shift i_s[2] dff_x1
Xshiftff[1] vdd vss i_s[2] sr_shift i_s[1] dff_x1
Xshiftff[0] vdd vss i_s[1] sr_shift sr_out dff_x1
Xlatchff[8] vdd vss i_s[8] sr_latch i[8] dff_x1
Xlatchff[7] vdd vss i_s[7] sr_latch i[7] dff_x1
Xlatchff[6] vdd vss i_s[6] sr_latch i[6] dff_x1
Xlatchff[5] vdd vss i_s[5] sr_latch i[5] dff_x1
Xlatchff[4] vdd vss i_s[4] sr_latch i[4] dff_x1
Xlatchff[3] vdd vss i_s[3] sr_latch i[3] dff_x1
Xlatchff[2] vdd vss i_s[2] sr_latch i[2] dff_x1
Xlatchff[1] vdd vss i_s[1] sr_latch i[1] dff_x1
Xlatchff[0] vdd vss sr_out sr_latch i[0] dff_x1
.ends SPDICETimingIn_9SF

.subckt SPDICETimingOut_2SL vss vdd sr_in sr_out sr_shift sr_latch l2s o[0] o[1]
Xshiftff[0] vdd vss o_m[0] sr_shift o_s[0] dff_x1
Xshiftff[1] vdd vss o_m[1] sr_shift sr_out dff_x1
Xlatchff[0] vdd vss o[0] sr_latch o_l[0] dff_x1
Xlatchff[1] vdd vss o[1] sr_latch o_l[1] dff_x1
Xmux[0] vdd vss sr_in o_l[0] l2s o_m[0] mux2_x1
Xmux[1] vdd vss o_s[0] o_l[1] l2s o_m[1] mux2_x1
.ends SPDICETimingOut_2SL

.subckt SPDICETimingIn_9SL vss vdd sr_in sr_out sr_shift sr_latch i[0] i[1] i[2] i[3] i[4] i[5] i[6] i[7] i[8]
Xshiftff[0] vdd vss sr_in sr_shift i_s[0] dff_x1
Xshiftff[1] vdd vss i_s[0] sr_shift i_s[1] dff_x1
Xshiftff[2] vdd vss i_s[1] sr_shift i_s[2] dff_x1
Xshiftff[3] vdd vss i_s[2] sr_shift i_s[3] dff_x1
Xshiftff[4] vdd vss i_s[3] sr_shift i_s[4] dff_x1
Xshiftff[5] vdd vss i_s[4] sr_shift i_s[5] dff_x1
Xshiftff[6] vdd vss i_s[5] sr_shift i_s[6] dff_x1
Xshiftff[7] vdd vss i_s[6] sr_shift i_s[7] dff_x1
Xshiftff[8] vdd vss i_s[7] sr_shift sr_out dff_x1
Xlatchff[0] vdd vss i_s[0] sr_latch i[0] dff_x1
Xlatchff[1] vdd vss i_s[1] sr_latch i[1] dff_x1
Xlatchff[2] vdd vss i_s[2] sr_latch i[2] dff_x1
Xlatchff[3] vdd vss i_s[3] sr_latch i[3] dff_x1
Xlatchff[4] vdd vss i_s[4] sr_latch i[4] dff_x1
Xlatchff[5] vdd vss i_s[5] sr_latch i[5] dff_x1
Xlatchff[6] vdd vss i_s[6] sr_latch i[6] dff_x1
Xlatchff[7] vdd vss i_s[7] sr_latch i[7] dff_x1
Xlatchff[8] vdd vss sr_out sr_latch i[8] dff_x1
.ends SPDICETimingIn_9SL

.subckt SPDICETimingOut_8SL vss vdd sr_in sr_out sr_shift sr_latch l2s o[0] o[1] o[2] o[3] o[4] o[5] o[6] o[7]
Xshiftff[0] vdd vss o_m[0] sr_shift o_s[0] dff_x1
Xshiftff[1] vdd vss o_m[1] sr_shift o_s[1] dff_x1
Xshiftff[2] vdd vss o_m[2] sr_shift o_s[2] dff_x1
Xshiftff[3] vdd vss o_m[3] sr_shift o_s[3] dff_x1
Xshiftff[4] vdd vss o_m[4] sr_shift o_s[4] dff_x1
Xshiftff[5] vdd vss o_m[5] sr_shift o_s[5] dff_x1
Xshiftff[6] vdd vss o_m[6] sr_shift o_s[6] dff_x1
Xshiftff[7] vdd vss o_m[7] sr_shift sr_out dff_x1
Xlatchff[0] vdd vss o[0] sr_latch o_l[0] dff_x1
Xlatchff[1] vdd vss o[1] sr_latch o_l[1] dff_x1
Xlatchff[2] vdd vss o[2] sr_latch o_l[2] dff_x1
Xlatchff[3] vdd vss o[3] sr_latch o_l[3] dff_x1
Xlatchff[4] vdd vss o[4] sr_latch o_l[4] dff_x1
Xlatchff[5] vdd vss o[5] sr_latch o_l[5] dff_x1
Xlatchff[6] vdd vss o[6] sr_latch o_l[6] dff_x1
Xlatchff[7] vdd vss o[7] sr_latch o_l[7] dff_x1
Xmux[0] vdd vss sr_in o_l[0] l2s o_m[0] mux2_x1
Xmux[1] vdd vss o_s[0] o_l[1] l2s o_m[1] mux2_x1
Xmux[2] vdd vss o_s[1] o_l[2] l2s o_m[2] mux2_x1
Xmux[3] vdd vss o_s[2] o_l[3] l2s o_m[3] mux2_x1
Xmux[4] vdd vss o_s[3] o_l[4] l2s o_m[4] mux2_x1
Xmux[5] vdd vss o_s[4] o_l[5] l2s o_m[5] mux2_x1
Xmux[6] vdd vss o_s[5] o_l[6] l2s o_m[6] mux2_x1
Xmux[7] vdd vss o_s[6] o_l[7] l2s o_m[7] mux2_x1
.ends SPDICETimingOut_8SL

.subckt SPDICEBlock_512x32_4we_C2B_R3B4B_Test vss vdd_block vdd_periph clk in_shift in_latch in_srin in_srout out_shift out_latch out_l2s out_srin out_srout
Xblock clk a[0] a[1] a[2] a[3] a[4] a[5] a[6] a[7] a[8] vss vdd_block q[0] q[1] q[2] q[3] q[4] q[5] q[6] q[7] q[8] q[9] q[10] q[11] q[12] q[13] q[14] q[15] q[16] q[17] q[18] q[19] q[20] q[21] q[22] q[23] q[24] q[25] q[26] q[27] q[28] q[29] q[30] q[31] d[0] d[1] d[2] d[3] d[4] d[5] d[6] d[7] d[8] d[9] d[10] d[11] d[12] d[13] d[14] d[15] d[16] d[17] d[18] d[19] d[20] d[21] d[22] d[23] d[24] d[25] d[26] d[27] d[28] d[29] d[30] d[31] we[0] we[1] we[2] we[3] SPDICEBlock_512x32_4we_C2B_R3B4B
Xasr vss vdd_periph in_srin in_srconn[0] in_shift in_latch a[8] a[7] a[6] a[5] a[4] a[3] a[2] a[1] a[0] SPDICETimingIn_9SF
Xclksr vss vdd_periph out_srin out_srconn[0] out_shift clk out_l2s in_latch out_latch SPDICETimingOut_2SL
Xdwesr[0] vss vdd_periph in_srconn[0] in_srconn[1] in_shift in_latch d[0] d[1] d[2] d[3] d[4] d[5] d[6] d[7] we[0] SPDICETimingIn_9SL
Xdwesr[1] vss vdd_periph in_srconn[1] in_srconn[2] in_shift in_latch d[8] d[9] d[10] d[11] d[12] d[13] d[14] d[15] we[1] SPDICETimingIn_9SL
Xdwesr[2] vss vdd_periph in_srconn[2] in_srconn[3] in_shift in_latch d[16] d[17] d[18] d[19] d[20] d[21] d[22] d[23] we[2] SPDICETimingIn_9SL
Xdwesr[3] vss vdd_periph in_srconn[3] in_srout in_shift in_latch d[24] d[25] d[26] d[27] d[28] d[29] d[30] d[31] we[3] SPDICETimingIn_9SL
Xqsr[0] vss vdd_periph out_srconn[0] out_srconn[1] out_shift out_latch out_l2s q[0] q[1] q[2] q[3] q[4] q[5] q[6] q[7] SPDICETimingOut_8SL
Xqsr[1] vss vdd_periph out_srconn[1] out_srconn[2] out_shift out_latch out_l2s q[8] q[9] q[10] q[11] q[12] q[13] q[14] q[15] SPDICETimingOut_8SL
Xqsr[2] vss vdd_periph out_srconn[2] out_srconn[3] out_shift out_latch out_l2s q[16] q[17] q[18] q[19] q[20] q[21] q[22] q[23] SPDICETimingOut_8SL
Xqsr[3] vss vdd_periph out_srconn[3] out_srout out_shift out_latch out_l2s q[24] q[25] q[26] q[27] q[28] q[29] q[30] q[31] SPDICETimingOut_8SL
Xinsrin_antdio vdd_periph vss in_srin diode_w1
Xinshift_antdio vdd_periph vss in_shift diode_w1
Xinlatch_antdio vdd_periph vss in_latch diode_w1
Xfill[0] vdd_periph vss tie_w2
Xfill[1] vdd_periph vss tie_w2
Xoutlatch_antdio vdd_periph vss out_latch diode_w1
Xoutshift_antdio vdd_periph vss out_shift diode_w1
Xoutsrin_antdio vdd_periph vss out_srin diode_w1
Xoutl2s_antdio vdd_periph vss out_l2s diode_w1
Xclk_antdio vdd_periph vss clk diode_w1
Xfill[2] vdd_periph vss tie_w2
Xfill[3] vdd_periph vss tie_w2
.ends SPDICEBlock_512x32_4we_C2B_R3B4B_Test

.subckt PadFrame_DICE PAD0x0 PAD0x1 PAD0x2 PAD0x3 PAD0x4 PAD0x5 PAD0x6 PAD0x7 PAD0x8 PAD0x9 PAD1x0 PAD1x1 PAD1x2 PAD1x3 PAD1x4 PAD1x5 PAD1x6 PAD1x7 PAD1x8 PAD1x9
XPAD0x0 PAD0x0 BondPad
XPAD0x1 PAD0x1 BondPad
XPAD0x2 PAD0x2 BondPad
XPAD0x3 PAD0x3 BondPad
XPAD0x4 PAD0x4 BondPad
XPAD0x5 PAD0x5 BondPad
XPAD0x6 PAD0x6 BondPad
XPAD0x7 PAD0x7 BondPad
XPAD0x8 PAD0x8 BondPad
XPAD0x9 PAD0x9 BondPad
XPAD1x0 PAD1x0 BondPad
XPAD1x1 PAD1x1 BondPad
XPAD1x2 PAD1x2 BondPad
XPAD1x3 PAD1x3 BondPad
XPAD1x4 PAD1x4 BondPad
XPAD1x5 PAD1x5 BondPad
XPAD1x6 PAD1x6 BondPad
XPAD1x7 PAD1x7 BondPad
XPAD1x8 PAD1x8 BondPad
XPAD1x9 PAD1x9 BondPad
.ends PadFrame_DICE

.subckt DICE vss vdd_periph vdd_block in_srout out_srout clk out_latch out_shift out_l2s out_srin in_shift in_srin in_latch
Xtestblock vss vdd_block vdd_periph clk in_shift in_latch in_srin in_srout out_shift out_latch out_l2s out_srin out_srout SPDICEBlock_512x32_4we_C2B_R3B4B_Test
Xpadframe vdd_block vss clk out_shift out_srin in_srin in_latch noconn noconn noconn vdd_periph in_srout out_srout out_latch out_l2s in_shift noconn noconn noconn noconn PadFrame_DICE
.ends DICE

.subckt spdice_io clk in_srin in_latch in_shift out_srin out_latch out_shift out_l2s in_srout out_srout vdd_block
Xmem vss vdd_block_int vdd clk_int in_shift_int in_latch_int in_srin_int in_srout_int out_shift_int out_latch_int out_l2s_int out_srin_int out_srout_int SPDICEBlock_512x32_4we_C2B_R3B4B_Test
Xclk_bp clk BondPad
Xclk_io clk clk_int sg13g2_IOPadIn
Xin_srin_bp in_srin BondPad
Xin_srin_io in_srin in_srin_int sg13g2_IOPadIn
Xin_latch_bp in_latch BondPad
Xin_latch_io in_latch in_latch_int sg13g2_IOPadIn
Xin_shift_bp in_shift BondPad
Xin_shift_io in_shift in_shift_int sg13g2_IOPadIn
Xout_srin_bp out_srin BondPad
Xout_srin_io out_srin out_srin_int sg13g2_IOPadIn
Xout_latch_bp out_latch BondPad
Xout_latch_io out_latch out_latch_int sg13g2_IOPadIn
Xout_shift_bp out_shift BondPad
Xout_shift_io out_shift out_shift_int sg13g2_IOPadIn
Xout_l2s_bp out_l2s BondPad
Xout_l2s_io out_l2s out_l2s_int sg13g2_IOPadIn
Xin_srout_bp in_srout BondPad
Xin_srout_io in_srout in_srout_int sg13g2_IOPadOut30mA
Xout_srout_bp out_srout BondPad
Xout_srout_io out_srout out_srout_int sg13g2_IOPadOut30mA
Xvdd_block_bp vdd_block BondPad
Xvdd_block_io vdd_block vdd_block_int sg13g2_IOPadAnalog
Xiofill0  sg13g2_Filler10000
Xiofill1  sg13g2_Filler10000
Xiofill2  sg13g2_Filler10000
Xiofill3  sg13g2_Filler10000
Xiofill4  sg13g2_Filler10000
Xiofill5  sg13g2_Filler10000
Xiofill6  sg13g2_Filler10000
Xiofill7  sg13g2_Filler10000
Xiofill8  sg13g2_Filler10000
Xiofill9  sg13g2_Filler10000
.ends spdice_io

.subckt SPDICEClockGen_4S11341D1R0C4WL vss vdd clk wl_en decodeclk columnclk precharge_n we_en
Xnonovl vss vdd clk firststage[0] firststage[1] firststage[2] firstpulse firststage[4] secondstage[0] secondstage[1] secondstage[2] secondpulse secondstage[4] SPDICENonOvlClock_4S11341D1R
Xdecodeclkbuf vdd vss clk decodeclk buf_x1
Xcolumnclkbuf vdd vss clk columnclk buf_x1
Xprechargeinv vdd vss secondpulse precharge_n inv_x3
Xwlenbuf vdd vss delayed_wlen wl_en buf_x4
Xweenbuf vdd vss firstpulse we_en buf_x1
Xwlendelbuf[0] vdd vss firstpulse wlen_conn[0] Delay_buf_x1
Xwlendelbuf[1] vdd vss wlen_conn[0] wlen_conn[1] Delay_buf_x1
Xwlendelbuf[2] vdd vss wlen_conn[1] wlen_conn[2] Delay_buf_x1
Xwlendelbuf[3] vdd vss wlen_conn[2] delayed_wlen Delay_buf_x1
.ends SPDICEClockGen_4S11341D1R0C4WL

.subckt SPDICEClockGen_4S11341D1R1C2WL vss vdd clk delayed_clk wl_en decodeclk columnclk precharge_n we_en
Xnonovl vss vdd delayed_clk firststage[0] firststage[1] firststage[2] firstpulse firststage[4] secondstage[0] secondstage[1] secondstage[2] secondpulse secondstage[4] SPDICENonOvlClock_4S11341D1R
Xdecodeclkbuf vdd vss delayed_clk decodeclk buf_x1
Xcolumnclkbuf vdd vss delayed_clk columnclk buf_x1
Xprechargeinv vdd vss secondpulse precharge_n inv_x3
Xwlenbuf vdd vss delayed_wlen wl_en buf_x4
Xweenbuf vdd vss firstpulse we_en buf_x1
Xclkbuf[0] vdd vss clk clk_conn[0] Delay_buf_x1
Xclkbuf[1] vdd vss clk_conn[0] delayed_clk Delay_buf_x1
Xwlendelbuf[0] vdd vss firstpulse wlen_conn[0] Delay_buf_x1
Xwlendelbuf[1] vdd vss wlen_conn[0] delayed_wlen Delay_buf_x1
.ends SPDICEClockGen_4S11341D1R1C2WL

.subckt SPDICEClockGen_4S11341D1R1C0WL vss vdd clk delayed_clk wl_en decodeclk columnclk precharge_n we_en
Xnonovl vss vdd delayed_clk firststage[0] firststage[1] firststage[2] firstpulse firststage[4] secondstage[0] secondstage[1] secondstage[2] secondpulse secondstage[4] SPDICENonOvlClock_4S11341D1R
Xdecodeclkbuf vdd vss delayed_clk decodeclk buf_x1
Xcolumnclkbuf vdd vss delayed_clk columnclk buf_x1
Xprechargeinv vdd vss secondpulse precharge_n inv_x3
Xwlenbuf vdd vss firstpulse wl_en buf_x4
Xweenbuf vdd vss firstpulse we_en buf_x1
Xclkbuf[0] vdd vss clk clk_conn[0] Delay_buf_x1
Xclkbuf[1] vdd vss clk_conn[0] delayed_clk Delay_buf_x1
.ends SPDICEClockGen_4S11341D1R1C0WL

.subckt SPDICEBlock_512x32_4we_C2B_R3B4B_TMR2X clk a[0] a[1] a[2] a[3] a[4] a[5] a[6] a[7] a[8] vss vdd q[0] q[1] q[2] q[3] q[4] q[5] q[6] q[7] q[8] q[9] q[10] q[11] q[12] q[13] q[14] q[15] q[16] q[17] q[18] q[19] q[20] q[21] q[22] q[23] q[24] q[25] q[26] q[27] q[28] q[29] q[30] q[31] d[0] d[1] d[2] d[3] d[4] d[5] d[6] d[7] d[8] d[9] d[10] d[11] d[12] d[13] d[14] d[15] d[16] d[17] d[18] d[19] d[20] d[21] d[22] d[23] d[24] d[25] d[26] d[27] d[28] d[29] d[30] d[31] we[0] we[1] we[2] we[3]
Xcolumnblock vss vdd columnclk precharge_n we_en wl[0] wl[1] wl[2] wl[3] wl[4] wl[5] wl[6] wl[7] wl[8] wl[9] wl[10] wl[11] wl[12] wl[13] wl[14] wl[15] wl[16] wl[17] wl[18] wl[19] wl[20] wl[21] wl[22] wl[23] wl[24] wl[25] wl[26] wl[27] wl[28] wl[29] wl[30] wl[31] wl[32] wl[33] wl[34] wl[35] wl[36] wl[37] wl[38] wl[39] wl[40] wl[41] wl[42] wl[43] wl[44] wl[45] wl[46] wl[47] wl[48] wl[49] wl[50] wl[51] wl[52] wl[53] wl[54] wl[55] wl[56] wl[57] wl[58] wl[59] wl[60] wl[61] wl[62] wl[63] wl[64] wl[65] wl[66] wl[67] wl[68] wl[69] wl[70] wl[71] wl[72] wl[73] wl[74] wl[75] wl[76] wl[77] wl[78] wl[79] wl[80] wl[81] wl[82] wl[83] wl[84] wl[85] wl[86] wl[87] wl[88] wl[89] wl[90] wl[91] wl[92] wl[93] wl[94] wl[95] wl[96] wl[97] wl[98] wl[99] wl[100] wl[101] wl[102] wl[103] wl[104] wl[105] wl[106] wl[107] wl[108] wl[109] wl[110] wl[111] wl[112] wl[113] wl[114] wl[115] wl[116] wl[117] wl[118] wl[119] wl[120] wl[121] wl[122] wl[123] wl[124] wl[125] wl[126] wl[127] mux[0] mux[1] mux[2] mux[3] we[0] q[0] d[0] q[1] d[1] q[2] d[2] q[3] d[3] q[4] d[4] q[5] d[5] q[6] d[6] q[7] d[7] we[1] q[8] d[8] q[9] d[9] q[10] d[10] q[11] d[11] q[12] d[12] q[13] d[13] q[14] d[14] q[15] d[15] we[2] q[16] d[16] q[17] d[17] q[18] d[18] q[19] d[19] q[20] d[20] q[21] d[21] q[22] d[22] q[23] d[23] we[3] q[24] d[24] q[25] d[25] q[26] d[26] q[27] d[27] q[28] d[28] q[29] d[29] q[30] d[30] q[31] d[31] SPDICEColumnBlock_COL128R_CP8B_CM4MN26L580W1R_PC26L100W_4WE
Xwldrivercol vss vdd wl[0] wl_n[0] wl[1] wl_n[1] wl[2] wl_n[2] wl[3] wl_n[3] wl[4] wl_n[4] wl[5] wl_n[5] wl[6] wl_n[6] wl[7] wl_n[7] wl[8] wl_n[8] wl[9] wl_n[9] wl[10] wl_n[10] wl[11] wl_n[11] wl[12] wl_n[12] wl[13] wl_n[13] wl[14] wl_n[14] wl[15] wl_n[15] wl[16] wl_n[16] wl[17] wl_n[17] wl[18] wl_n[18] wl[19] wl_n[19] wl[20] wl_n[20] wl[21] wl_n[21] wl[22] wl_n[22] wl[23] wl_n[23] wl[24] wl_n[24] wl[25] wl_n[25] wl[26] wl_n[26] wl[27] wl_n[27] wl[28] wl_n[28] wl[29] wl_n[29] wl[30] wl_n[30] wl[31] wl_n[31] wl[32] wl_n[32] wl[33] wl_n[33] wl[34] wl_n[34] wl[35] wl_n[35] wl[36] wl_n[36] wl[37] wl_n[37] wl[38] wl_n[38] wl[39] wl_n[39] wl[40] wl_n[40] wl[41] wl_n[41] wl[42] wl_n[42] wl[43] wl_n[43] wl[44] wl_n[44] wl[45] wl_n[45] wl[46] wl_n[46] wl[47] wl_n[47] wl[48] wl_n[48] wl[49] wl_n[49] wl[50] wl_n[50] wl[51] wl_n[51] wl[52] wl_n[52] wl[53] wl_n[53] wl[54] wl_n[54] wl[55] wl_n[55] wl[56] wl_n[56] wl[57] wl_n[57] wl[58] wl_n[58] wl[59] wl_n[59] wl[60] wl_n[60] wl[61] wl_n[61] wl[62] wl_n[62] wl[63] wl_n[63] wl[64] wl_n[64] wl[65] wl_n[65] wl[66] wl_n[66] wl[67] wl_n[67] wl[68] wl_n[68] wl[69] wl_n[69] wl[70] wl_n[70] wl[71] wl_n[71] wl[72] wl_n[72] wl[73] wl_n[73] wl[74] wl_n[74] wl[75] wl_n[75] wl[76] wl_n[76] wl[77] wl_n[77] wl[78] wl_n[78] wl[79] wl_n[79] wl[80] wl_n[80] wl[81] wl_n[81] wl[82] wl_n[82] wl[83] wl_n[83] wl[84] wl_n[84] wl[85] wl_n[85] wl[86] wl_n[86] wl[87] wl_n[87] wl[88] wl_n[88] wl[89] wl_n[89] wl[90] wl_n[90] wl[91] wl_n[91] wl[92] wl_n[92] wl[93] wl_n[93] wl[94] wl_n[94] wl[95] wl_n[95] wl[96] wl_n[96] wl[97] wl_n[97] wl[98] wl_n[98] wl[99] wl_n[99] wl[100] wl_n[100] wl[101] wl_n[101] wl[102] wl_n[102] wl[103] wl_n[103] wl[104] wl_n[104] wl[105] wl_n[105] wl[106] wl_n[106] wl[107] wl_n[107] wl[108] wl_n[108] wl[109] wl_n[109] wl[110] wl_n[110] wl[111] wl_n[111] wl[112] wl_n[112] wl[113] wl_n[113] wl[114] wl_n[114] wl[115] wl_n[115] wl[116] wl_n[116] wl[117] wl_n[117] wl[118] wl_n[118] wl[119] wl_n[119] wl[120] wl_n[120] wl[121] wl_n[121] wl[122] wl_n[122] wl[123] wl_n[123] wl[124] wl_n[124] wl[125] wl_n[125] wl[126] wl_n[126] wl[127] wl_n[127] SPDICEWLDriverCol_128RN26L400WP26L800W
Xclkgen1 vss vdd clk wl_en1 decodeclk1 columnclk precharge_n we_en SPDICEClockGen_4S11341D1R0C4WL
Xclkgen2 vss vdd clk delayed_clk wl_en2 decodeclk2 noconn_columnclk2 noconn_precharge_n2 noconn_we_en2 SPDICEClockGen_4S11341D1R1C2WL
Xclkgen3 vss vdd delayed_clk noconn_clk wl_en3 decodeclk3 noconn_columnclk3 noconn_precharge_n3 noconn_we_en3 SPDICEClockGen_4S11341D1R1C0WL
Xrowperiph1 vss vdd a[0] a[1] a[2] a[3] a[4] a[5] a[6] a[7] a[8] wl_n[0] wl_n[1] wl_n[2] wl_n[3] wl_n[4] wl_n[5] wl_n[6] wl_n[7] wl_n[8] wl_n[9] wl_n[10] wl_n[11] wl_n[12] wl_n[13] wl_n[14] wl_n[15] wl_n[16] wl_n[17] wl_n[18] wl_n[19] wl_n[20] wl_n[21] wl_n[22] wl_n[23] wl_n[24] wl_n[25] wl_n[26] wl_n[27] wl_n[28] wl_n[29] wl_n[30] wl_n[31] wl_n[32] wl_n[33] wl_n[34] wl_n[35] wl_n[36] wl_n[37] wl_n[38] wl_n[39] wl_n[40] wl_n[41] wl_n[42] wl_n[43] wl_n[44] wl_n[45] wl_n[46] wl_n[47] wl_n[48] wl_n[49] wl_n[50] wl_n[51] wl_n[52] wl_n[53] wl_n[54] wl_n[55] wl_n[56] wl_n[57] wl_n[58] wl_n[59] wl_n[60] wl_n[61] wl_n[62] wl_n[63] wl_n[64] wl_n[65] wl_n[66] wl_n[67] wl_n[68] wl_n[69] wl_n[70] wl_n[71] wl_n[72] wl_n[73] wl_n[74] wl_n[75] wl_n[76] wl_n[77] wl_n[78] wl_n[79] wl_n[80] wl_n[81] wl_n[82] wl_n[83] wl_n[84] wl_n[85] wl_n[86] wl_n[87] wl_n[88] wl_n[89] wl_n[90] wl_n[91] wl_n[92] wl_n[93] wl_n[94] wl_n[95] wl_n[96] wl_n[97] wl_n[98] wl_n[99] wl_n[100] wl_n[101] wl_n[102] wl_n[103] wl_n[104] wl_n[105] wl_n[106] wl_n[107] wl_n[108] wl_n[109] wl_n[110] wl_n[111] wl_n[112] wl_n[113] wl_n[114] wl_n[115] wl_n[116] wl_n[117] wl_n[118] wl_n[119] wl_n[120] wl_n[121] wl_n[122] wl_n[123] wl_n[124] wl_n[125] wl_n[126] wl_n[127] decodeclk1 wl_en1 mux[0] mux[1] mux[2] mux[3] SPDICERowPeriph_PD3B4B_LD2B2R
Xrowperiph2 vss vdd a[0] a[1] a[2] a[3] a[4] a[5] a[6] a[7] a[8] wl_n[0] wl_n[1] wl_n[2] wl_n[3] wl_n[4] wl_n[5] wl_n[6] wl_n[7] wl_n[8] wl_n[9] wl_n[10] wl_n[11] wl_n[12] wl_n[13] wl_n[14] wl_n[15] wl_n[16] wl_n[17] wl_n[18] wl_n[19] wl_n[20] wl_n[21] wl_n[22] wl_n[23] wl_n[24] wl_n[25] wl_n[26] wl_n[27] wl_n[28] wl_n[29] wl_n[30] wl_n[31] wl_n[32] wl_n[33] wl_n[34] wl_n[35] wl_n[36] wl_n[37] wl_n[38] wl_n[39] wl_n[40] wl_n[41] wl_n[42] wl_n[43] wl_n[44] wl_n[45] wl_n[46] wl_n[47] wl_n[48] wl_n[49] wl_n[50] wl_n[51] wl_n[52] wl_n[53] wl_n[54] wl_n[55] wl_n[56] wl_n[57] wl_n[58] wl_n[59] wl_n[60] wl_n[61] wl_n[62] wl_n[63] wl_n[64] wl_n[65] wl_n[66] wl_n[67] wl_n[68] wl_n[69] wl_n[70] wl_n[71] wl_n[72] wl_n[73] wl_n[74] wl_n[75] wl_n[76] wl_n[77] wl_n[78] wl_n[79] wl_n[80] wl_n[81] wl_n[82] wl_n[83] wl_n[84] wl_n[85] wl_n[86] wl_n[87] wl_n[88] wl_n[89] wl_n[90] wl_n[91] wl_n[92] wl_n[93] wl_n[94] wl_n[95] wl_n[96] wl_n[97] wl_n[98] wl_n[99] wl_n[100] wl_n[101] wl_n[102] wl_n[103] wl_n[104] wl_n[105] wl_n[106] wl_n[107] wl_n[108] wl_n[109] wl_n[110] wl_n[111] wl_n[112] wl_n[113] wl_n[114] wl_n[115] wl_n[116] wl_n[117] wl_n[118] wl_n[119] wl_n[120] wl_n[121] wl_n[122] wl_n[123] wl_n[124] wl_n[125] wl_n[126] wl_n[127] decodeclk2 wl_en2 mux[0] mux[1] mux[2] mux[3] SPDICERowPeriph_PD3B4B_LD2B2R
Xrowperiph3 vss vdd a[0] a[1] a[2] a[3] a[4] a[5] a[6] a[7] a[8] wl_n[0] wl_n[1] wl_n[2] wl_n[3] wl_n[4] wl_n[5] wl_n[6] wl_n[7] wl_n[8] wl_n[9] wl_n[10] wl_n[11] wl_n[12] wl_n[13] wl_n[14] wl_n[15] wl_n[16] wl_n[17] wl_n[18] wl_n[19] wl_n[20] wl_n[21] wl_n[22] wl_n[23] wl_n[24] wl_n[25] wl_n[26] wl_n[27] wl_n[28] wl_n[29] wl_n[30] wl_n[31] wl_n[32] wl_n[33] wl_n[34] wl_n[35] wl_n[36] wl_n[37] wl_n[38] wl_n[39] wl_n[40] wl_n[41] wl_n[42] wl_n[43] wl_n[44] wl_n[45] wl_n[46] wl_n[47] wl_n[48] wl_n[49] wl_n[50] wl_n[51] wl_n[52] wl_n[53] wl_n[54] wl_n[55] wl_n[56] wl_n[57] wl_n[58] wl_n[59] wl_n[60] wl_n[61] wl_n[62] wl_n[63] wl_n[64] wl_n[65] wl_n[66] wl_n[67] wl_n[68] wl_n[69] wl_n[70] wl_n[71] wl_n[72] wl_n[73] wl_n[74] wl_n[75] wl_n[76] wl_n[77] wl_n[78] wl_n[79] wl_n[80] wl_n[81] wl_n[82] wl_n[83] wl_n[84] wl_n[85] wl_n[86] wl_n[87] wl_n[88] wl_n[89] wl_n[90] wl_n[91] wl_n[92] wl_n[93] wl_n[94] wl_n[95] wl_n[96] wl_n[97] wl_n[98] wl_n[99] wl_n[100] wl_n[101] wl_n[102] wl_n[103] wl_n[104] wl_n[105] wl_n[106] wl_n[107] wl_n[108] wl_n[109] wl_n[110] wl_n[111] wl_n[112] wl_n[113] wl_n[114] wl_n[115] wl_n[116] wl_n[117] wl_n[118] wl_n[119] wl_n[120] wl_n[121] wl_n[122] wl_n[123] wl_n[124] wl_n[125] wl_n[126] wl_n[127] decodeclk3 wl_en3 mux[0] mux[1] mux[2] mux[3] SPDICERowPeriph_PD3B4B_LD2B2R
.ends SPDICEBlock_512x32_4we_C2B_R3B4B_TMR2X

.subckt SPDICEBlock_512x32_4we_C2B_R3B4B_TMR2X_Test vss vdd_block vdd_periph clk in_shift in_latch in_srin in_srout out_shift out_latch out_l2s out_srin out_srout
Xblock clk a[0] a[1] a[2] a[3] a[4] a[5] a[6] a[7] a[8] vss vdd_block q[0] q[1] q[2] q[3] q[4] q[5] q[6] q[7] q[8] q[9] q[10] q[11] q[12] q[13] q[14] q[15] q[16] q[17] q[18] q[19] q[20] q[21] q[22] q[23] q[24] q[25] q[26] q[27] q[28] q[29] q[30] q[31] d[0] d[1] d[2] d[3] d[4] d[5] d[6] d[7] d[8] d[9] d[10] d[11] d[12] d[13] d[14] d[15] d[16] d[17] d[18] d[19] d[20] d[21] d[22] d[23] d[24] d[25] d[26] d[27] d[28] d[29] d[30] d[31] we[0] we[1] we[2] we[3] SPDICEBlock_512x32_4we_C2B_R3B4B_TMR2X
Xasr vss vdd_periph in_srin in_srconn[0] in_shift in_latch a[8] a[7] a[6] a[5] a[4] a[3] a[2] a[1] a[0] SPDICETimingIn_9SF
Xclksr vss vdd_periph out_srin out_srconn[0] out_shift clk out_l2s in_latch out_latch SPDICETimingOut_2SL
Xdwesr[0] vss vdd_periph in_srconn[0] in_srconn[1] in_shift in_latch d[0] d[1] d[2] d[3] d[4] d[5] d[6] d[7] we[0] SPDICETimingIn_9SL
Xdwesr[1] vss vdd_periph in_srconn[1] in_srconn[2] in_shift in_latch d[8] d[9] d[10] d[11] d[12] d[13] d[14] d[15] we[1] SPDICETimingIn_9SL
Xdwesr[2] vss vdd_periph in_srconn[2] in_srconn[3] in_shift in_latch d[16] d[17] d[18] d[19] d[20] d[21] d[22] d[23] we[2] SPDICETimingIn_9SL
Xdwesr[3] vss vdd_periph in_srconn[3] in_srout in_shift in_latch d[24] d[25] d[26] d[27] d[28] d[29] d[30] d[31] we[3] SPDICETimingIn_9SL
Xqsr[0] vss vdd_periph out_srconn[0] out_srconn[1] out_shift out_latch out_l2s q[0] q[1] q[2] q[3] q[4] q[5] q[6] q[7] SPDICETimingOut_8SL
Xqsr[1] vss vdd_periph out_srconn[1] out_srconn[2] out_shift out_latch out_l2s q[8] q[9] q[10] q[11] q[12] q[13] q[14] q[15] SPDICETimingOut_8SL
Xqsr[2] vss vdd_periph out_srconn[2] out_srconn[3] out_shift out_latch out_l2s q[16] q[17] q[18] q[19] q[20] q[21] q[22] q[23] SPDICETimingOut_8SL
Xqsr[3] vss vdd_periph out_srconn[3] out_srout out_shift out_latch out_l2s q[24] q[25] q[26] q[27] q[28] q[29] q[30] q[31] SPDICETimingOut_8SL
Xinsrin_antdio vdd_periph vss in_srin diode_w1
Xinshift_antdio vdd_periph vss in_shift diode_w1
Xinlatch_antdio vdd_periph vss in_latch diode_w1
Xfill[0] vdd_periph vss tie_w2
Xfill[1] vdd_periph vss tie_w2
Xoutlatch_antdio vdd_periph vss out_latch diode_w1
Xoutshift_antdio vdd_periph vss out_shift diode_w1
Xoutsrin_antdio vdd_periph vss out_srin diode_w1
Xoutl2s_antdio vdd_periph vss out_l2s diode_w1
Xclk_antdio vdd_periph vss clk diode_w1
Xfill[2] vdd_periph vss tie_w2
Xfill[3] vdd_periph vss tie_w2
.ends SPDICEBlock_512x32_4we_C2B_R3B4B_TMR2X_Test

.subckt PadFrame_TMRD PAD0x0 PAD0x1 PAD0x2 PAD0x3 PAD0x4 PAD0x5 PAD0x6 PAD0x7 PAD0x8 PAD0x9 PAD1x0 PAD1x1 PAD1x2 PAD1x3 PAD1x4 PAD1x5 PAD1x6 PAD1x7 PAD1x8 PAD1x9
XPAD0x0 PAD0x0 BondPad
XPAD0x1 PAD0x1 BondPad
XPAD0x2 PAD0x2 BondPad
XPAD0x3 PAD0x3 BondPad
XPAD0x4 PAD0x4 BondPad
XPAD0x5 PAD0x5 BondPad
XPAD0x6 PAD0x6 BondPad
XPAD0x7 PAD0x7 BondPad
XPAD0x8 PAD0x8 BondPad
XPAD0x9 PAD0x9 BondPad
XPAD1x0 PAD1x0 BondPad
XPAD1x1 PAD1x1 BondPad
XPAD1x2 PAD1x2 BondPad
XPAD1x3 PAD1x3 BondPad
XPAD1x4 PAD1x4 BondPad
XPAD1x5 PAD1x5 BondPad
XPAD1x6 PAD1x6 BondPad
XPAD1x7 PAD1x7 BondPad
XPAD1x8 PAD1x8 BondPad
XPAD1x9 PAD1x9 BondPad
.ends PadFrame_TMRD

.subckt TMRD vss vdd_periph vdd_block in_srout out_srout clk out_latch out_shift out_l2s out_srin in_shift in_srin in_latch
Xtestblock vss vdd_block vdd_periph clk in_shift in_latch in_srin in_srout out_shift out_latch out_l2s out_srin out_srout SPDICEBlock_512x32_4we_C2B_R3B4B_TMR2X_Test
Xpadframe vdd_block vss clk out_shift out_srin in_srin in_latch noconn noconn noconn vdd_periph in_srout out_srout out_latch out_l2s in_shift noconn noconn noconn noconn PadFrame_TMRD
.ends TMRD

.subckt spdicetmr_io clk in_srin in_latch in_shift out_srin out_latch out_shift out_l2s in_srout out_srout vdd_block
Xmem vss vdd_block_int vdd clk_int in_shift_int in_latch_int in_srin_int in_srout_int out_shift_int out_latch_int out_l2s_int out_srin_int out_srout_int SPDICEBlock_512x32_4we_C2B_R3B4B_TMR2X_Test
Xclk_bp clk BondPad
Xclk_io clk clk_int sg13g2_IOPadIn
Xin_srin_bp in_srin BondPad
Xin_srin_io in_srin in_srin_int sg13g2_IOPadIn
Xin_latch_bp in_latch BondPad
Xin_latch_io in_latch in_latch_int sg13g2_IOPadIn
Xin_shift_bp in_shift BondPad
Xin_shift_io in_shift in_shift_int sg13g2_IOPadIn
Xout_srin_bp out_srin BondPad
Xout_srin_io out_srin out_srin_int sg13g2_IOPadIn
Xout_latch_bp out_latch BondPad
Xout_latch_io out_latch out_latch_int sg13g2_IOPadIn
Xout_shift_bp out_shift BondPad
Xout_shift_io out_shift out_shift_int sg13g2_IOPadIn
Xout_l2s_bp out_l2s BondPad
Xout_l2s_io out_l2s out_l2s_int sg13g2_IOPadIn
Xin_srout_bp in_srout BondPad
Xin_srout_io in_srout in_srout_int sg13g2_IOPadOut30mA
Xout_srout_bp out_srout BondPad
Xout_srout_io out_srout out_srout_int sg13g2_IOPadOut30mA
Xvdd_block_bp vdd_block BondPad
Xvdd_block_io vdd_block vdd_block_int sg13g2_IOPadAnalog
Xiofill0  sg13g2_Filler10000
Xiofill1  sg13g2_Filler10000
Xiofill2  sg13g2_Filler10000
Xiofill3  sg13g2_Filler10000
Xiofill4  sg13g2_Filler10000
Xiofill5  sg13g2_Filler10000
Xiofill6  sg13g2_Filler10000
Xiofill7  sg13g2_Filler10000
Xiofill8  sg13g2_Filler10000
Xiofill9  sg13g2_Filler10000
.ends spdicetmr_io

.subckt RadHardSRAMTest vss vdd iovss iovdd sp6t1_vdd_block_io sp6t1_clk_io sp6t1_in_shift_io sp6t1_in_latch_io sp6t1_in_srin_io sp6t1_in_srout_io sp6t1_out_shift_io sp6t1_out_latch_io sp6t1_out_l2s_io sp6t1_out_srin_io sp6t1_out_srout_io sp6t1_vss_frame sp6t1_vdd_periph_frame sp6t1_vdd_block_frame sp6t1_clk_frame sp6t1_in_shift_frame sp6t1_in_latch_frame sp6t1_in_srin_frame sp6t1_in_srout_frame sp6t1_out_shift_frame sp6t1_out_latch_frame sp6t1_out_l2s_frame sp6t1_out_srin_frame sp6t1_out_srout_frame sp6t2_vdd_block_io sp6t2_clk_io sp6t2_in_shift_io sp6t2_in_latch_io sp6t2_in_srin_io sp6t2_in_srout_io sp6t2_out_shift_io sp6t2_out_latch_io sp6t2_out_l2s_io sp6t2_out_srin_io sp6t2_out_srout_io sp6t2_vss_frame sp6t2_vdd_periph_frame sp6t2_vdd_block_frame sp6t2_clk_frame sp6t2_in_shift_frame sp6t2_in_latch_frame sp6t2_in_srin_frame sp6t2_in_srout_frame sp6t2_out_shift_frame sp6t2_out_latch_frame sp6t2_out_l2s_frame sp6t2_out_srin_frame sp6t2_out_srout_frame sp6t3_vdd_block_io sp6t3_clk_io sp6t3_in_shift_io sp6t3_in_latch_io sp6t3_in_srin_io sp6t3_in_srout_io sp6t3_out_shift_io sp6t3_out_latch_io sp6t3_out_l2s_io sp6t3_out_srin_io sp6t3_out_srout_io sp6t3_vss_frame sp6t3_vdd_periph_frame sp6t3_vdd_block_frame sp6t3_clk_frame sp6t3_in_shift_frame sp6t3_in_latch_frame sp6t3_in_srin_frame sp6t3_in_srout_frame sp6t3_out_shift_frame sp6t3_out_latch_frame sp6t3_out_l2s_frame sp6t3_out_srin_frame sp6t3_out_srout_frame spdice1_vdd_block_io spdice1_clk_io spdice1_in_shift_io spdice1_in_latch_io spdice1_in_srin_io spdice1_in_srout_io spdice1_out_shift_io spdice1_out_latch_io spdice1_out_l2s_io spdice1_out_srin_io spdice1_out_srout_io spdice1_vdd spdice1_vss_frame spdice1_vdd_periph_frame spdice1_vdd_block_frame spdice1_clk_frame spdice1_in_shift_frame spdice1_in_latch_frame spdice1_in_srin_frame spdice1_in_srout_frame spdice1_out_shift_frame spdice1_out_latch_frame spdice1_out_l2s_frame spdice1_out_srin_frame spdice1_out_srout_frame sp6ttmr_vdd_block_io sp6ttmr_clk_io sp6ttmr_in_shift_io sp6ttmr_in_latch_io sp6ttmr_in_srin_io sp6ttmr_in_srout_io sp6ttmr_out_shift_io sp6ttmr_out_latch_io sp6ttmr_out_l2s_io sp6ttmr_out_srin_io sp6ttmr_out_srout_io sp6ttmr_vss_frame sp6ttmr_vdd_periph_frame sp6ttmr_vdd_block_frame sp6ttmr_clk_frame sp6ttmr_in_shift_frame sp6ttmr_in_latch_frame sp6ttmr_in_srin_frame sp6ttmr_in_srout_frame sp6ttmr_out_shift_frame sp6ttmr_out_latch_frame sp6ttmr_out_l2s_frame sp6ttmr_out_srin_frame sp6ttmr_out_srout_frame spdicetmr_vdd_block_io spdicetmr_clk_io spdicetmr_in_shift_io spdicetmr_in_latch_io spdicetmr_in_srin_io spdicetmr_in_srout_io spdicetmr_out_shift_io spdicetmr_out_latch_io spdicetmr_out_l2s_io spdicetmr_out_srin_io spdicetmr_out_srout_io spdicetmr_vss_frame spdicetmr_vdd_periph_frame spdicetmr_vdd_block_frame spdicetmr_clk_frame spdicetmr_in_shift_frame spdicetmr_in_latch_frame spdicetmr_in_srin_frame spdicetmr_in_srout_frame spdicetmr_out_shift_frame spdicetmr_out_latch_frame spdicetmr_out_l2s_frame spdicetmr_out_srin_frame spdicetmr_out_srout_frame
Xswcorner  sg13g2_Corner
Xsecorner  sg13g2_Corner
Xnecorner  sg13g2_Corner
Xnwcorner  sg13g2_Corner
Xlldcio vss vdd iovss iovdd sg13g2_DCIO10000
Xsp6t1_io sp6t1_clk_io sp6t1_in_srin_io sp6t1_in_latch_io sp6t1_in_shift_io sp6t1_out_srin_io sp6t1_out_latch_io sp6t1_out_shift_io sp6t1_out_l2s_io sp6t1_in_srout_io sp6t1_out_srout_io sp6t1_vdd_block_io sp6t1_io
Xtlfill  sg13g2_Filler4000
Xtldcio vss vdd iovss iovdd sg13g2_DCIO10000
Xsp6t1frame sp6t1_vss_frame sp6t1_vdd_periph_frame sp6t1_vdd_block_frame sp6t1_in_srout_frame sp6t1_out_srout_frame sp6t1_clk_frame sp6t1_out_latch_frame sp6t1_out_shift_frame sp6t1_out_l2s_frame sp6t1_out_srin_frame sp6t1_in_shift_frame sp6t1_in_srin_frame sp6t1_in_latch_frame SP01
Xlrdcio vss vdd iovss iovdd sg13g2_DCIO10000
Xsp6t2_io sp6t2_clk_io sp6t2_in_srin_io sp6t2_in_latch_io sp6t2_in_shift_io sp6t2_out_srin_io sp6t2_out_latch_io sp6t2_out_shift_io sp6t2_out_l2s_io sp6t2_in_srout_io sp6t2_out_srout_io sp6t2_vdd_block_io sp6t2_io
Xtrfill  sg13g2_Filler4000
Xtrdcio vss vdd iovss iovdd sg13g2_DCIO10000
Xsp6t2frame sp6t2_vss_frame sp6t2_vdd_periph_frame sp6t2_vdd_block_frame sp6t2_in_srout_frame sp6t2_out_srout_frame sp6t2_clk_frame sp6t2_out_latch_frame sp6t2_out_shift_frame sp6t2_out_l2s_frame sp6t2_out_srin_frame sp6t2_in_shift_frame sp6t2_in_srin_frame sp6t2_in_latch_frame SP02
Xsp6t3_io sp6t3_clk_io sp6t3_in_srin_io sp6t3_in_latch_io sp6t3_in_shift_io sp6t3_out_srin_io sp6t3_out_latch_io sp6t3_out_shift_io sp6t3_out_l2s_io sp6t3_in_srout_io sp6t3_out_srout_io sp6t3_vdd_block_io sp6t3_io
Xbotfill1  sg13g2_Filler4000
Xbotfill2  sg13g2_Filler20000
Xbotdcio vss vdd iovss iovdd sg13g2_DCIO10000
Xbotfill3  sg13g2_Filler2000
Xbotfill4  sg13g2_Filler20000
Xsp6t3frame sp6t3_vss_frame sp6t3_vdd_periph_frame sp6t3_vdd_block_frame sp6t3_in_srout_frame sp6t3_out_srout_frame sp6t3_clk_frame sp6t3_out_latch_frame sp6t3_out_shift_frame sp6t3_out_l2s_frame sp6t3_out_srin_frame sp6t3_in_shift_frame sp6t3_in_srin_frame sp6t3_in_latch_frame SP03
Xspdice1_io spdice1_clk_io spdice1_in_srin_io spdice1_in_latch_io spdice1_in_shift_io spdice1_out_srin_io spdice1_out_latch_io spdice1_out_shift_io spdice1_out_l2s_io spdice1_in_srout_io spdice1_out_srout_io spdice1_vdd_block_io spdice_io
Xtopfill1  sg13g2_Filler4000
Xtopfill2  sg13g2_Filler20000
Xtopdcio vss vdd iovss iovdd sg13g2_DCIO10000
Xtopfill3  sg13g2_Filler2000
Xtopfill4  sg13g2_Filler20000
Xspdice1frame spdice1_vss_frame spdice1_vdd_periph_frame spdice1_vdd_block_frame spdice1_in_srout_frame spdice1_out_srout_frame spdice1_clk_frame spdice1_out_latch_frame spdice1_out_shift_frame spdice1_out_l2s_frame spdice1_out_srin_frame spdice1_in_shift_frame spdice1_in_srin_frame spdice1_in_latch_frame DICE
Xsp6ttmr_io sp6ttmr_clk_io sp6ttmr_in_srin_io sp6ttmr_in_latch_io sp6ttmr_in_shift_io sp6ttmr_out_srin_io sp6ttmr_out_latch_io sp6ttmr_out_shift_io sp6ttmr_out_l2s_io sp6ttmr_in_srout_io sp6ttmr_out_srout_io sp6ttmr_vdd_block_io sp6ttmr_io
Xsp6ttmrframe sp6ttmr_vss_frame sp6ttmr_vdd_periph_frame sp6ttmr_vdd_block_frame sp6ttmr_in_srout_frame sp6ttmr_out_srout_frame sp6ttmr_clk_frame sp6ttmr_out_latch_frame sp6ttmr_out_shift_frame sp6ttmr_out_l2s_frame sp6ttmr_out_srin_frame sp6ttmr_in_shift_frame sp6ttmr_in_srin_frame sp6ttmr_in_latch_frame TMRR
Xspdicetmr_io spdicetmr_clk_io spdicetmr_in_srin_io spdicetmr_in_latch_io spdicetmr_in_shift_io spdicetmr_out_srin_io spdicetmr_out_latch_io spdicetmr_out_shift_io spdicetmr_out_l2s_io spdicetmr_in_srout_io spdicetmr_out_srout_io spdicetmr_vdd_block_io spdicetmr_io
Xspdicetmrframe spdicetmr_vss_frame spdicetmr_vdd_periph_frame spdicetmr_vdd_block_frame spdicetmr_in_srout_frame spdicetmr_out_srout_frame spdicetmr_clk_frame spdicetmr_out_latch_frame spdicetmr_out_shift_frame spdicetmr_out_l2s_frame spdicetmr_out_srin_frame spdicetmr_in_shift_frame spdicetmr_in_srin_frame spdicetmr_in_latch_frame TMRD
.ends RadHardSRAMTest
