* Extracted by KLayout with SG13G2 LVS runset on : 14/04/2026 10:11

.SUBCKT TMRR vss in_srout vdd_block vdd_periph out_srout out_latch clk
+ out_shift out_srin out_l2s in_srin in_shift in_latch
X$2 vss out_l2s out_shift out_srout vdd_periph out_srin clk out_latch in_shift
+ in_srin in_srout in_latch vdd_block SP6T2Block_512x32_4we_C2B_R3B4B_TMR2X_Test
.ENDS TMRR

.SUBCKT SP6T2Block_512x32_4we_C2B_R3B4B_TMR2X_Test vss out_l2s out_shift
+ out_srout vdd_periph out_srin clk out_latch in_shift in_srin in_srout
+ in_latch vdd_block
X$1 vss clk \$65 \$15 \$66 \$16 \$67 \$17 \$68 \$18 \$69 \$19 \$70 \$20 \$97
+ \$21 \$71 \$22 \$72 \$73 \$23 \$74 \$24 \$75 \$25 \$76 \$26 \$77 \$27 \$78
+ \$28 \$98 \$29 \$79 \$30 \$80 \$81 \$31 \$82 \$32 \$83 \$33 \$84 \$34 \$85
+ \$35 \$86 \$36 \$99 \$37 \$87 \$38 \$88 \$89 \$39 \$90 \$40 \$91 \$41 \$92
+ \$42 \$93 \$43 \$94 \$44 \$100 \$45 \$95 \$46 \$96 vdd_block \$64 \$63 \$62
+ \$61 \$60 \$59 \$58 \$57 \$56 SP6T2Block_512x32_4we_C2B_R3B4B_TMR2X
X$2 vss in_shift \$49 vdd_periph \$50 in_latch \$65 \$66 \$67 \$68 \$69 \$70
+ \$97 \$71 \$72 SP6T2TimingIn_9SL
X$3 vss out_shift out_l2s \$9 vdd_periph \$8 out_latch \$15 \$16 \$17 \$18 \$19
+ \$20 \$21 \$22 SP6T2TimingOut_8SL
X$6 vss in_shift \$50 vdd_periph \$51 in_latch \$73 \$74 \$75 \$76 \$77 \$78
+ \$98 \$79 \$80 SP6T2TimingIn_9SL
X$7 vss out_shift out_l2s \$10 vdd_periph \$9 out_latch \$23 \$24 \$25 \$26
+ \$27 \$28 \$29 \$30 SP6T2TimingOut_8SL
X$8 vss in_shift \$52 vdd_periph in_srout in_latch \$89 \$90 \$91 \$92 \$93
+ \$94 \$100 \$95 \$96 SP6T2TimingIn_9SL
X$9 vss out_shift out_l2s out_srout vdd_periph \$11 out_latch \$39 \$40 \$41
+ \$42 \$43 \$44 \$45 \$46 SP6T2TimingOut_8SL
X$10 vss in_shift \$51 vdd_periph \$52 in_latch \$81 \$82 \$83 \$84 \$85 \$86
+ \$99 \$87 \$88 SP6T2TimingIn_9SL
X$11 vss out_shift out_l2s \$11 vdd_periph \$10 out_latch \$31 \$32 \$33 \$34
+ \$35 \$36 \$37 \$38 SP6T2TimingOut_8SL
X$12 vss in_shift in_srin vdd_periph \$49 in_latch \$56 \$57 \$58 \$59 \$60
+ \$61 \$62 \$63 \$64 SP6T2TimingIn_9SF
X$19 vss vdd_periph out_shift out_l2s in_latch out_latch clk out_srin \$8
+ SP6T2TimingOut_2SL
.ENDS SP6T2Block_512x32_4we_C2B_R3B4B_TMR2X_Test

.SUBCKT SP6T2TimingOut_2SL vss vdd sr_shift l2s o[0] o[1] sr_latch sr_in sr_out
X$1 vss \$11 \$10 sr_shift vdd dff_x1
X$2 vss o[0] \$12 sr_latch vdd dff_x1
X$3 vdd vss l2s sr_in \$12 \$11 mux2_x1
X$4 vdd vss l2s \$10 \$15 \$14 mux2_x1
X$5 vss \$14 sr_out sr_shift vdd dff_x1
X$6 vss o[1] \$15 sr_latch vdd dff_x1
.ENDS SP6T2TimingOut_2SL

.SUBCKT SP6T2TimingOut_8SL vss sr_shift l2s sr_out vdd sr_in sr_latch o[0] o[1]
+ o[2] o[3] o[4] o[5] o[6] o[7]
X$1 vss \$9 \$10 sr_shift vdd dff_x1
X$2 vss o[0] \$25 sr_latch vdd dff_x1
X$3 vdd vss l2s sr_in \$25 \$9 mux2_x1
X$4 vdd vss l2s \$10 \$5 \$11 mux2_x1
X$5 vss \$11 \$12 sr_shift vdd dff_x1
X$6 vss o[1] \$5 sr_latch vdd dff_x1
X$7 vss \$13 \$14 sr_shift vdd dff_x1
X$8 vss o[2] \$26 sr_latch vdd dff_x1
X$9 vdd vss l2s \$12 \$26 \$13 mux2_x1
X$10 vdd vss l2s \$14 \$6 \$15 mux2_x1
X$11 vss \$15 \$16 sr_shift vdd dff_x1
X$12 vss o[3] \$6 sr_latch vdd dff_x1
X$13 vss \$17 \$18 sr_shift vdd dff_x1
X$14 vss o[4] \$28 sr_latch vdd dff_x1
X$15 vdd vss l2s \$16 \$28 \$17 mux2_x1
X$16 vdd vss l2s \$18 \$7 \$19 mux2_x1
X$17 vss \$19 \$20 sr_shift vdd dff_x1
X$18 vss o[5] \$7 sr_latch vdd dff_x1
X$19 vss \$21 \$22 sr_shift vdd dff_x1
X$20 vss o[6] \$29 sr_latch vdd dff_x1
X$21 vdd vss l2s \$20 \$29 \$21 mux2_x1
X$22 vdd vss l2s \$22 \$8 \$23 mux2_x1
X$23 vss \$23 sr_out sr_shift vdd dff_x1
X$24 vss o[7] \$8 sr_latch vdd dff_x1
.ENDS SP6T2TimingOut_8SL

.SUBCKT SP6T2TimingIn_9SL vss sr_shift sr_in vdd sr_out sr_latch i[0] i[1] i[2]
+ i[3] i[4] i[5] i[6] i[7] i[8]
X$1 vss sr_in \$5 sr_shift vdd dff_x1
X$2 vss \$5 i[0] sr_latch vdd dff_x1
X$3 vss \$5 \$6 sr_shift vdd dff_x1
X$4 vss \$6 i[1] sr_latch vdd dff_x1
X$5 vss \$6 \$7 sr_shift vdd dff_x1
X$6 vss \$7 i[2] sr_latch vdd dff_x1
X$7 vss \$7 \$8 sr_shift vdd dff_x1
X$8 vss \$8 i[3] sr_latch vdd dff_x1
X$9 vss \$8 \$9 sr_shift vdd dff_x1
X$10 vss \$9 i[4] sr_latch vdd dff_x1
X$11 vss \$9 \$10 sr_shift vdd dff_x1
X$12 vss \$10 i[5] sr_latch vdd dff_x1
X$13 vss \$10 \$11 sr_shift vdd dff_x1
X$14 vss \$11 i[6] sr_latch vdd dff_x1
X$15 vss \$11 \$12 sr_shift vdd dff_x1
X$16 vss \$12 i[7] sr_latch vdd dff_x1
X$17 vss \$12 sr_out sr_shift vdd dff_x1
X$18 vss sr_out i[8] sr_latch vdd dff_x1
.ENDS SP6T2TimingIn_9SL

.SUBCKT SP6T2TimingIn_9SF vss sr_shift sr_in vdd sr_out sr_latch i[8] i[7] i[6]
+ i[5] i[4] i[3] i[2] i[1] i[0]
X$1 vss sr_in \$5 sr_shift vdd dff_x1
X$2 vss \$5 i[8] sr_latch vdd dff_x1
X$3 vss \$5 \$6 sr_shift vdd dff_x1
X$4 vss \$6 i[7] sr_latch vdd dff_x1
X$5 vss \$6 \$7 sr_shift vdd dff_x1
X$6 vss \$7 i[6] sr_latch vdd dff_x1
X$7 vss \$7 \$8 sr_shift vdd dff_x1
X$8 vss \$8 i[5] sr_latch vdd dff_x1
X$9 vss \$8 \$9 sr_shift vdd dff_x1
X$10 vss \$9 i[4] sr_latch vdd dff_x1
X$11 vss \$9 \$10 sr_shift vdd dff_x1
X$12 vss \$10 i[3] sr_latch vdd dff_x1
X$13 vss \$10 \$11 sr_shift vdd dff_x1
X$14 vss \$11 i[2] sr_latch vdd dff_x1
X$15 vss \$11 \$12 sr_shift vdd dff_x1
X$16 vss \$12 i[1] sr_latch vdd dff_x1
X$17 vss \$12 sr_out sr_shift vdd dff_x1
X$18 vss sr_out i[0] sr_latch vdd dff_x1
.ENDS SP6T2TimingIn_9SF

.SUBCKT SP6T2Block_512x32_4we_C2B_R3B4B_TMR2X vss clk d[0] q[0] d[1] q[1] d[2]
+ q[2] d[3] q[3] d[4] q[4] d[5] q[5] d[6] q[6] d[7] q[7] we[0] d[8] q[8] d[9]
+ q[9] d[10] q[10] d[11] q[11] d[12] q[12] d[13] q[13] d[14] q[14] d[15] q[15]
+ we[1] d[16] q[16] d[17] q[17] d[18] q[18] d[19] q[19] d[20] q[20] d[21] q[21]
+ d[22] q[22] d[23] q[23] we[2] d[24] q[24] d[25] q[25] d[26] q[26] d[27] q[27]
+ d[28] q[28] d[29] q[29] d[30] q[30] d[31] q[31] we[3] vdd a[0] a[1] a[2] a[3]
+ a[4] a[5] a[6] a[7] a[8]
X$1 vss a[0] \$86 vdd \$6 \$85 a[1] \$90 \$92 a[2] \$98 \$101 \$99 \$100 \$97
+ \$115 \$112 \$114 \$111 \$113 a[3] \$126 \$125 \$130 \$127 \$128 \$129 \$142
+ \$146 a[4] \$144 \$143 \$147 \$157 \$145 \$159 \$156 \$160 a[5] \$158 \$174
+ \$172 \$173 \$170 \$176 \$171 \$175 a[6] \$189 \$191 \$190 \$192 \$188 \$208
+ \$203 \$207 \$204 \$206 a[7] \$205 \$223 \$219 \$222 \$220 \$221 \$218 \$236
+ a[8] \$234 \$238 \$235 \$237 \$246 \$247 \$245 \$248 \$254 \$258 \$253 \$256
+ \$255 \$8 \$268 \$257 \$269 \$266 \$270 \$267 \$280 \$277 \$281 \$278 \$279
+ \$287 \$291 \$289 \$292 \$288 \$290 \$302 \$305 \$303 \$304 \$301 \$313 \$311
+ \$312 \$310 \$314 \$322 \$326 \$323 \$324 \$321 \$325 \$337 \$338 \$335 \$339
+ \$336 \$346 \$345 \$348 \$344 \$347 \$357 \$359 \$356 \$360 \$355 \$358 \$369
+ \$372 \$370 \$373 \$371 \$381 \$379 \$382 \$378 \$380 \$390 \$392 \$389 \$391
+ SP6T2RowPeriph_PD3B4B_LD2B2R
X$2 vss a[0] \$86 vdd \$3 \$85 a[1] \$90 \$92 a[2] \$98 \$101 \$99 \$100 \$97
+ \$115 \$112 \$114 \$111 \$113 a[3] \$126 \$125 \$130 \$127 \$128 \$129 \$142
+ \$146 a[4] \$144 \$143 \$147 \$157 \$145 \$159 \$156 \$160 a[5] \$158 \$174
+ \$172 \$173 \$170 \$176 \$171 \$175 a[6] \$189 \$191 \$190 \$192 \$188 \$208
+ \$203 \$207 \$204 \$206 a[7] \$205 \$223 \$219 \$222 \$220 \$221 \$218 \$236
+ a[8] \$234 \$238 \$235 \$237 \$246 \$247 \$245 \$248 \$254 \$258 \$253 \$256
+ \$255 \$5 \$268 \$257 \$269 \$266 \$270 \$267 \$280 \$277 \$281 \$278 \$279
+ \$287 \$291 \$289 \$292 \$288 \$290 \$302 \$305 \$303 \$304 \$301 \$313 \$311
+ \$312 \$310 \$314 \$322 \$326 \$323 \$324 \$321 \$325 \$337 \$338 \$335 \$339
+ \$336 \$346 \$345 \$348 \$344 \$347 \$357 \$359 \$356 \$360 \$355 \$358 \$369
+ \$372 \$370 \$373 \$371 \$381 \$379 \$382 \$378 \$380 \$390 \$392 \$389 \$391
+ SP6T2RowPeriph_PD3B4B_LD2B2R
X$3 vss a[0] \$86 vdd \$9 \$85 a[1] \$90 \$92 a[2] \$98 \$101 \$99 \$100 \$97
+ \$115 \$112 \$114 \$111 \$113 a[3] \$126 \$125 \$130 \$127 \$128 \$129 \$142
+ \$146 a[4] \$144 \$143 \$147 \$157 \$145 \$159 \$156 \$160 a[5] \$158 \$174
+ \$172 \$173 \$170 \$176 \$171 \$175 a[6] \$189 \$191 \$190 \$192 \$188 \$208
+ \$203 \$207 \$204 \$206 a[7] \$205 \$223 \$219 \$222 \$220 \$221 \$218 \$236
+ a[8] \$234 \$238 \$235 \$237 \$246 \$247 \$245 \$248 \$254 \$258 \$253 \$256
+ \$255 \$10 \$268 \$257 \$269 \$266 \$270 \$267 \$280 \$277 \$281 \$278 \$279
+ \$287 \$291 \$289 \$292 \$288 \$290 \$302 \$305 \$303 \$304 \$301 \$313 \$311
+ \$312 \$310 \$314 \$322 \$326 \$323 \$324 \$321 \$325 \$337 \$338 \$335 \$339
+ \$336 \$346 \$345 \$348 \$344 \$347 \$357 \$359 \$356 \$360 \$355 \$358 \$369
+ \$372 \$370 \$373 \$371 \$381 \$379 \$382 \$378 \$380 \$390 \$392 \$389 \$391
+ SP6T2RowPeriph_PD3B4B_LD2B2R
X$4 vss vdd \$98 \$101 \$109 \$106 \$99 \$108 \$100 \$97 \$107 \$122 \$115
+ \$112 \$124 \$119 \$114 \$121 \$111 \$113 \$120 \$123 \$126 \$136 \$130 \$125
+ \$140 \$139 \$128 \$127 \$138 \$137 \$129 \$135 \$142 \$152 \$146 \$144 \$154
+ \$153 \$147 \$151 \$143 \$145 \$168 \$150 \$157 \$165 \$159 \$156 \$164 \$166
+ \$160 \$158 \$167 \$169 \$174 \$183 \$172 \$173 \$186 \$182 \$170 \$185 \$176
+ \$181 \$175 \$171 \$184 \$196 \$189 \$198 \$191 \$190 \$197 \$201 \$192 \$188
+ \$199 \$200 \$208 \$214 \$203 \$207 \$217 \$216 \$204 \$212 \$206 \$205 \$215
+ \$213 \$223 \$219 \$228 \$230 \$222 \$231 \$220 \$229 \$221 \$218 \$232 \$241
+ \$236 \$242 \$234 \$238 \$239 \$240 \$235 \$243 \$237 \$246 \$244 \$251 \$247
+ \$245 \$252 \$249 \$248 \$250 \$254 \$258 \$265 \$261 \$253 \$262 \$256 \$263
+ \$255 \$264 \$257 \$268 \$275 \$276 \$269 \$272 \$266 \$270 \$273 \$274 \$267
+ \$271 \$280 \$277 \$284 \$285 \$281 \$278 \$286 \$282 \$279 \$283 \$287 \$291
+ \$295 \$296 \$289 \$300 \$292 \$297 \$290 \$288 \$299 \$298 \$302 \$309 \$305
+ \$303 \$306 \$308 \$304 \$301 \$307 \$316 \$313 \$319 \$311 \$312 \$320 \$318
+ \$310 \$317 \$314 \$322 \$315 \$329 \$326 \$323 \$330 \$334 \$324 \$331 \$321
+ \$333 \$325 \$337 \$332 \$341 \$338 \$340 \$335 \$339 \$343 \$342 \$336 \$350
+ \$346 \$345 \$349 \$351 \$348 \$344 \$354 \$353 \$347 \$352 \$357 \$359 \$363
+ \$364 \$356 \$368 \$360 \$365 \$358 \$355 \$367 \$366 \$369 \$375 \$372 \$370
+ \$374 \$376 \$373 \$371 \$377 \$385 \$381 \$388 \$379 \$382 \$387 \$386 \$378
+ \$384 \$380 \$390 \$383 \$395 \$392 \$389 \$398 \$396 \$391 \$397
+ SP6T2WLDriverCol_128RN26L400WP26L800W
X$5 vss vdd clk \$9 \$10 \$11 \$80 \$81 SP6T2ClockGen_4S11341D1R0C4WL
X$6 vss d[0] q[0] d[1] q[1] d[2] q[2] d[3] q[3] d[4] q[4] d[5] q[5] d[6] q[6]
+ d[7] q[7] we[0] d[8] q[8] d[9] q[9] d[10] q[10] d[11] q[11] d[12] q[12] d[13]
+ q[13] d[14] q[14] d[15] q[15] we[1] d[16] q[16] d[17] q[17] d[18] q[18] d[19]
+ q[19] \$80 \$81 d[20] q[20] d[21] q[21] d[22] q[22] d[23] q[23] we[2] d[24]
+ q[24] d[25] q[25] d[26] q[26] d[27] q[27] d[28] q[28] d[29] q[29] d[30] q[30]
+ d[31] q[31] we[3] vdd \$86 \$85 \$90 \$92 \$11 \$183 \$199 \$201 \$197 \$198
+ \$196 \$184 \$181 \$185 \$186 \$200 \$169 \$167 \$166 \$164 \$165 \$168 \$150
+ \$151 \$153 \$251 \$244 \$243 \$239 \$240 \$242 \$241 \$232 \$229 \$182 \$231
+ \$230 \$228 \$213 \$215 \$212 \$216 \$217 \$214 \$124 \$137 \$138 \$139 \$140
+ \$136 \$120 \$121 \$119 \$123 \$122 \$107 \$108 \$106 \$109 \$135 \$152 \$154
+ \$317 \$329 \$315 \$330 \$334 \$331 \$343 \$318 \$320 \$319 \$316 \$307 \$308
+ \$306 \$309 \$299 \$297 \$300 \$353 \$375 \$366 \$367 \$365 \$368 \$364 \$363
+ \$352 \$354 \$351 \$349 \$350 \$298 \$342 \$340 \$341 \$332 \$333 \$261 \$263
+ \$284 \$285 \$262 \$271 \$286 \$265 \$273 \$282 \$264 \$274 \$250 \$283 \$272
+ \$249 \$275 \$295 \$276 \$252 \$296 \$388 \$374 \$376 \$377 \$397 \$385 \$395
+ \$396 \$387 \$386 \$398 \$384 \$383
+ SP6T2ColumnBlock_COL128R_CP8B_CM4MN26L580W1R_PC26L100W_4WE
X$7 vss vdd \$4 clk \$6 \$8 SP6T2ClockGen_4S11341D1R1C2WL
X$8 vss vdd \$4 \$3 \$5 SP6T2ClockGen_4S11341D1R1C0WL
.ENDS SP6T2Block_512x32_4we_C2B_R3B4B_TMR2X

.SUBCKT mux2_x1 vdd vss cmd i0 i1 q
M$1 \$1 cmd vss vss sg13_lv_nmos L=0.13u W=0.78u AS=0.2652p AD=0.1482p PS=2.24u
+ PD=1.16u
M$2 vss i0 \$9 vss sg13_lv_nmos L=0.13u W=0.78u AS=0.1482p AD=0.1482p PS=1.16u
+ PD=1.16u
M$3 \$9 \$1 \$6 vss sg13_lv_nmos L=0.13u W=0.78u AS=0.1482p AD=0.195p PS=1.16u
+ PD=1.28u
M$4 \$6 cmd \$10 vss sg13_lv_nmos L=0.13u W=0.78u AS=0.195p AD=0.1482p PS=1.28u
+ PD=1.16u
M$5 \$10 i1 vss vss sg13_lv_nmos L=0.13u W=0.78u AS=0.1482p AD=0.2092p PS=1.16u
+ PD=1.48u
M$6 vss \$6 q vss sg13_lv_nmos L=0.13u W=1.07u AS=0.2092p AD=0.3638p PS=1.48u
+ PD=2.82u
M$7 \$1 cmd vdd vdd sg13_lv_pmos L=0.13u W=0.78u AS=0.2652p AD=0.1482p PS=2.24u
+ PD=1.16u
M$8 vdd i0 \$11 vdd sg13_lv_pmos L=0.13u W=0.78u AS=0.1482p AD=0.1482p PS=1.16u
+ PD=1.16u
M$9 \$11 cmd \$6 vdd sg13_lv_pmos L=0.13u W=0.78u AS=0.1482p AD=0.195p PS=1.16u
+ PD=1.28u
M$10 \$6 \$1 \$12 vdd sg13_lv_pmos L=0.13u W=0.78u AS=0.195p AD=0.1482p
+ PS=1.28u PD=1.16u
M$11 vdd i1 \$12 vdd sg13_lv_pmos L=0.13u W=0.78u AS=0.2075p AD=0.1482p
+ PS=1.47u PD=1.16u
M$12 vdd \$6 q vdd sg13_lv_pmos L=0.13u W=1.06u AS=0.2075p AD=0.3604p PS=1.47u
+ PD=2.8u
.ENDS mux2_x1

.SUBCKT SP6T2ClockGen_4S11341D1R1C0WL vss vdd clk decodeclk wl_en
X$1 vdd vss delayed_clk decodeclk buf_x1
X$2 vdd vss \$9 wl_en buf_x4
X$3 vss vdd precharge_n \$12 inv_x3
X$4 vdd vss delayed_clk columnclk buf_x1
X$5 vss vdd \$9 \$12 delayed_clk SP6T2NonOvlClock_4S11341D1R
X$6 vdd vss \$9 we_en buf_x1
X$7 vdd vss \$5 delayed_clk Delay_buf_x1
X$8 vdd vss clk \$5 Delay_buf_x1
.ENDS SP6T2ClockGen_4S11341D1R1C0WL

.SUBCKT SP6T2ClockGen_4S11341D1R1C2WL vss vdd delayed_clk clk decodeclk wl_en
X$1 vdd vss delayed_clk decodeclk buf_x1
X$2 vdd vss \$11 wl_en buf_x4
X$3 vss vdd precharge_n \$14 inv_x3
X$4 vdd vss \$10 \$11 Delay_buf_x1
X$5 vdd vss \$9 \$10 Delay_buf_x1
X$6 vdd vss delayed_clk columnclk buf_x1
X$7 vss vdd \$9 \$14 delayed_clk SP6T2NonOvlClock_4S11341D1R
X$8 vdd vss \$9 we_en buf_x1
X$9 vdd vss \$5 delayed_clk Delay_buf_x1
X$10 vdd vss clk \$5 Delay_buf_x1
.ENDS SP6T2ClockGen_4S11341D1R1C2WL

.SUBCKT SP6T2ClockGen_4S11341D1R0C4WL vss vdd clk decodeclk wl_en precharge_n
+ columnclk we_en
X$1 vdd vss clk decodeclk buf_x1
X$2 vdd vss \$11 wl_en buf_x4
X$3 vss vdd precharge_n \$14 inv_x3
X$4 vdd vss \$10 \$11 Delay_buf_x1
X$5 vdd vss \$9 \$10 Delay_buf_x1
X$6 vdd vss \$8 \$9 Delay_buf_x1
X$7 vdd vss \$7 \$8 Delay_buf_x1
X$8 vdd vss clk columnclk buf_x1
X$9 vss vdd \$7 \$14 clk SP6T2NonOvlClock_4S11341D1R
X$10 vdd vss \$7 we_en buf_x1
.ENDS SP6T2ClockGen_4S11341D1R0C4WL

.SUBCKT SP6T2ColumnBlock_COL128R_CP8B_CM4MN26L580W1R_PC26L100W_4WE vss d[0]
+ q[0] d[1] q[1] d[2] q[2] d[3] q[3] d[4] q[4] d[5] q[5] d[6] q[6] d[7] q[7]
+ we[0] d[8] q[8] d[9] q[9] d[10] q[10] d[11] q[11] d[12] q[12] d[13] q[13]
+ d[14] q[14] d[15] q[15] we[1] d[16] q[16] d[17] q[17] d[18] q[18] d[19] q[19]
+ clk we_en d[20] q[20] d[21] q[21] d[22] q[22] d[23] q[23] we[2] d[24] q[24]
+ d[25] q[25] d[26] q[26] d[27] q[27] d[28] q[28] d[29] q[29] d[30] q[30] d[31]
+ q[31] we[3] vdd mux[0] mux[1] mux[2] mux[3] precharge_n wl[27] wl[37] wl[36]
+ wl[35] wl[34] wl[33] wl[32] wl[31] wl[30] wl[29] wl[38] wl[26] wl[25] wl[24]
+ wl[23] wl[22] wl[21] wl[20] wl[19] wl[18] wl[56] wl[55] wl[54] wl[53] wl[52]
+ wl[51] wl[50] wl[49] wl[48] wl[28] wl[47] wl[46] wl[45] wl[44] wl[43] wl[42]
+ wl[41] wl[40] wl[39] wl[5] wl[14] wl[13] wl[12] wl[11] wl[10] wl[8] wl[7]
+ wl[6] wl[9] wl[4] wl[3] wl[2] wl[1] wl[0] wl[15] wl[16] wl[17] wl[90] wl[92]
+ wl[91] wl[93] wl[94] wl[95] wl[101] wl[89] wl[88] wl[87] wl[86] wl[85] wl[84]
+ wl[83] wl[82] wl[80] wl[79] wl[78] wl[106] wl[114] wl[113] wl[112] wl[111]
+ wl[110] wl[109] wl[108] wl[107] wl[105] wl[104] wl[103] wl[102] wl[81]
+ wl[100] wl[99] wl[98] wl[97] wl[96] wl[60] wl[63] wl[71] wl[72] wl[62] wl[70]
+ wl[73] wl[61] wl[69] wl[74] wl[64] wl[68] wl[59] wl[75] wl[67] wl[58] wl[65]
+ wl[76] wl[66] wl[57] wl[77] wl[119] wl[115] wl[116] wl[117] wl[127] wl[118]
+ wl[124] wl[126] wl[120] wl[121] wl[125] wl[122] wl[123]
X$1 vss d[8] q[8] d[9] q[9] d[10] q[10] d[11] q[11] d[12] q[12] d[13] q[13]
+ d[14] q[14] d[15] q[15] we[1] clk we_en mux[0] vdd mux[2] mux[3] mux[1] wl[2]
+ precharge_n wl[0] wl[1] wl[8] wl[11] wl[10] wl[3] wl[4] wl[5] wl[6] wl[7]
+ wl[9] wl[12] wl[22] wl[20] wl[19] wl[21] wl[23] wl[18] wl[24] wl[25] wl[17]
+ wl[26] wl[27] wl[15] wl[14] wl[13] wl[16] wl[40] wl[39] wl[38] wl[37] wl[36]
+ wl[35] wl[28] wl[34] wl[33] wl[32] wl[42] wl[43] wl[29] wl[30] wl[31] wl[41]
+ wl[59] wl[54] wl[49] wl[58] wl[50] wl[57] wl[51] wl[56] wl[52] wl[55] wl[53]
+ wl[47] wl[46] wl[45] wl[44] wl[48] wl[67] wl[68] wl[66] wl[69] wl[70] wl[71]
+ wl[65] wl[72] wl[75] wl[73] wl[64] wl[74] wl[60] wl[61] wl[63] wl[62] wl[91]
+ wl[86] wl[81] wl[90] wl[89] wl[82] wl[88] wl[83] wl[84] wl[87] wl[85] wl[79]
+ wl[78] wl[77] wl[76] wl[80] wl[99] wl[100] wl[98] wl[101] wl[102] wl[103]
+ wl[97] wl[104] wl[107] wl[105] wl[96] wl[106] wl[92] wl[93] wl[95] wl[94]
+ wl[123] wl[118] wl[113] wl[122] wl[121] wl[114] wl[120] wl[115] wl[116]
+ wl[119] wl[117] wl[111] wl[110] wl[109] wl[108] wl[112] wl[127] wl[126]
+ wl[125] wl[124] SP6T2Column_128R_CP8B_CM4MN26L580W1R_PC26L100W
X$2 vss d[0] q[0] d[1] q[1] d[2] q[2] d[3] q[3] d[4] q[4] d[5] q[5] d[6] q[6]
+ d[7] q[7] we[0] clk we_en mux[0] vdd mux[2] mux[3] mux[1] wl[2] precharge_n
+ wl[0] wl[1] wl[8] wl[11] wl[10] wl[3] wl[4] wl[5] wl[6] wl[7] wl[9] wl[12]
+ wl[22] wl[20] wl[19] wl[21] wl[23] wl[18] wl[24] wl[25] wl[17] wl[26] wl[27]
+ wl[15] wl[14] wl[13] wl[16] wl[40] wl[39] wl[38] wl[37] wl[36] wl[35] wl[28]
+ wl[34] wl[33] wl[32] wl[42] wl[43] wl[29] wl[30] wl[31] wl[41] wl[59] wl[54]
+ wl[49] wl[58] wl[50] wl[57] wl[51] wl[56] wl[52] wl[55] wl[53] wl[47] wl[46]
+ wl[45] wl[44] wl[48] wl[67] wl[68] wl[66] wl[69] wl[70] wl[71] wl[65] wl[72]
+ wl[75] wl[73] wl[64] wl[74] wl[60] wl[61] wl[63] wl[62] wl[91] wl[86] wl[81]
+ wl[90] wl[89] wl[82] wl[88] wl[83] wl[84] wl[87] wl[85] wl[79] wl[78] wl[77]
+ wl[76] wl[80] wl[99] wl[100] wl[98] wl[101] wl[102] wl[103] wl[97] wl[104]
+ wl[107] wl[105] wl[96] wl[106] wl[92] wl[93] wl[95] wl[94] wl[123] wl[118]
+ wl[113] wl[122] wl[121] wl[114] wl[120] wl[115] wl[116] wl[119] wl[117]
+ wl[111] wl[110] wl[109] wl[108] wl[112] wl[127] wl[126] wl[125] wl[124]
+ SP6T2Column_128R_CP8B_CM4MN26L580W1R_PC26L100W
X$3 vss d[16] q[16] d[17] q[17] d[18] q[18] d[19] q[19] d[20] q[20] d[21] q[21]
+ d[22] q[22] d[23] q[23] we[2] clk we_en mux[0] vdd mux[2] mux[3] mux[1] wl[2]
+ precharge_n wl[0] wl[1] wl[8] wl[11] wl[10] wl[3] wl[4] wl[5] wl[6] wl[7]
+ wl[9] wl[12] wl[22] wl[20] wl[19] wl[21] wl[23] wl[18] wl[24] wl[25] wl[17]
+ wl[26] wl[27] wl[15] wl[14] wl[13] wl[16] wl[40] wl[39] wl[38] wl[37] wl[36]
+ wl[35] wl[28] wl[34] wl[33] wl[32] wl[42] wl[43] wl[29] wl[30] wl[31] wl[41]
+ wl[59] wl[54] wl[49] wl[58] wl[50] wl[57] wl[51] wl[56] wl[52] wl[55] wl[53]
+ wl[47] wl[46] wl[45] wl[44] wl[48] wl[67] wl[68] wl[66] wl[69] wl[70] wl[71]
+ wl[65] wl[72] wl[75] wl[73] wl[64] wl[74] wl[60] wl[61] wl[63] wl[62] wl[91]
+ wl[86] wl[81] wl[90] wl[89] wl[82] wl[88] wl[83] wl[84] wl[87] wl[85] wl[79]
+ wl[78] wl[77] wl[76] wl[80] wl[99] wl[100] wl[98] wl[101] wl[102] wl[103]
+ wl[97] wl[104] wl[107] wl[105] wl[96] wl[106] wl[92] wl[93] wl[95] wl[94]
+ wl[123] wl[118] wl[113] wl[122] wl[121] wl[114] wl[120] wl[115] wl[116]
+ wl[119] wl[117] wl[111] wl[110] wl[109] wl[108] wl[112] wl[127] wl[126]
+ wl[125] wl[124] SP6T2Column_128R_CP8B_CM4MN26L580W1R_PC26L100W
X$4 vss d[24] q[24] d[25] q[25] d[26] q[26] d[27] q[27] d[28] q[28] d[29] q[29]
+ d[30] q[30] d[31] q[31] we[3] clk we_en mux[0] vdd mux[2] mux[3] mux[1] wl[2]
+ precharge_n wl[0] wl[1] wl[8] wl[11] wl[10] wl[3] wl[4] wl[5] wl[6] wl[7]
+ wl[9] wl[12] wl[22] wl[20] wl[19] wl[21] wl[23] wl[18] wl[24] wl[25] wl[17]
+ wl[26] wl[27] wl[15] wl[14] wl[13] wl[16] wl[40] wl[39] wl[38] wl[37] wl[36]
+ wl[35] wl[28] wl[34] wl[33] wl[32] wl[42] wl[43] wl[29] wl[30] wl[31] wl[41]
+ wl[59] wl[54] wl[49] wl[58] wl[50] wl[57] wl[51] wl[56] wl[52] wl[55] wl[53]
+ wl[47] wl[46] wl[45] wl[44] wl[48] wl[67] wl[68] wl[66] wl[69] wl[70] wl[71]
+ wl[65] wl[72] wl[75] wl[73] wl[64] wl[74] wl[60] wl[61] wl[63] wl[62] wl[91]
+ wl[86] wl[81] wl[90] wl[89] wl[82] wl[88] wl[83] wl[84] wl[87] wl[85] wl[79]
+ wl[78] wl[77] wl[76] wl[80] wl[99] wl[100] wl[98] wl[101] wl[102] wl[103]
+ wl[97] wl[104] wl[107] wl[105] wl[96] wl[106] wl[92] wl[93] wl[95] wl[94]
+ wl[123] wl[118] wl[113] wl[122] wl[121] wl[114] wl[120] wl[115] wl[116]
+ wl[119] wl[117] wl[111] wl[110] wl[109] wl[108] wl[112] wl[127] wl[126]
+ wl[125] wl[124] SP6T2Column_128R_CP8B_CM4MN26L580W1R_PC26L100W
.ENDS SP6T2ColumnBlock_COL128R_CP8B_CM4MN26L580W1R_PC26L100W_4WE

.SUBCKT SP6T2WLDriverCol_128RN26L400WP26L800W vss vdd wl_n[0] wl_n[1] wl[0]
+ wl[1] wl_n[2] wl[2] wl_n[3] wl_n[4] wl[3] wl[4] wl_n[5] wl_n[6] wl[5] wl[6]
+ wl_n[7] wl[7] wl_n[8] wl_n[9] wl[8] wl[9] wl_n[10] wl[10] wl_n[11] wl_n[12]
+ wl[11] wl[12] wl_n[13] wl_n[14] wl[13] wl[14] wl_n[15] wl[15] wl_n[16] wl[16]
+ wl_n[17] wl_n[18] wl[17] wl[18] wl_n[19] wl[19] wl_n[20] wl_n[21] wl[21]
+ wl[20] wl_n[22] wl[22] wl_n[23] wl_n[24] wl[23] wl[24] wl_n[25] wl_n[26]
+ wl[25] wl[26] wl_n[27] wl[27] wl_n[28] wl_n[29] wl[29] wl[28] wl_n[30] wl[30]
+ wl_n[31] wl[31] wl_n[33] wl_n[32] wl[32] wl[33] wl_n[34] wl[34] wl_n[35]
+ wl_n[36] wl[35] wl[36] wl_n[37] wl_n[38] wl[37] wl[38] wl_n[39] wl[39]
+ wl_n[40] wl_n[41] wl[40] wl[41] wl_n[42] wl[42] wl_n[43] wl_n[44] wl[43]
+ wl[44] wl_n[45] wl_n[46] wl[45] wl[46] wl_n[47] wl[47] wl_n[48] wl[48]
+ wl_n[49] wl_n[50] wl[49] wl[50] wl_n[51] wl[51] wl_n[52] wl_n[53] wl[53]
+ wl[52] wl_n[54] wl[54] wl_n[55] wl_n[56] wl[55] wl[56] wl_n[57] wl_n[58]
+ wl[57] wl[58] wl_n[59] wl[59] wl_n[60] wl_n[61] wl[61] wl[60] wl_n[62] wl[62]
+ wl_n[63] wl[63] wl_n[64] wl[64] wl_n[65] wl_n[66] wl[65] wl[66] wl_n[67]
+ wl[67] wl_n[68] wl_n[69] wl[69] wl[68] wl_n[70] wl[70] wl_n[71] wl_n[72]
+ wl[71] wl[72] wl_n[73] wl_n[74] wl[73] wl[74] wl_n[75] wl[75] wl_n[76]
+ wl_n[77] wl[76] wl[77] wl_n[78] wl[78] wl_n[79] wl[79] wl_n[81] wl_n[80]
+ wl[80] wl[81] wl_n[82] wl[82] wl_n[83] wl_n[84] wl[83] wl[84] wl_n[85]
+ wl_n[86] wl[85] wl[86] wl_n[87] wl[87] wl_n[88] wl_n[89] wl[88] wl[89]
+ wl_n[90] wl[90] wl_n[91] wl_n[92] wl[91] wl[92] wl_n[93] wl_n[94] wl[93]
+ wl[94] wl_n[95] wl[95] wl_n[96] wl[96] wl_n[97] wl_n[98] wl[97] wl[98]
+ wl_n[99] wl[99] wl_n[100] wl_n[101] wl[101] wl[100] wl_n[102] wl[102]
+ wl_n[103] wl_n[104] wl[103] wl[104] wl_n[105] wl_n[106] wl[105] wl[106]
+ wl_n[107] wl[107] wl_n[108] wl_n[109] wl[108] wl[109] wl_n[110] wl[110]
+ wl_n[111] wl[111] wl_n[113] wl_n[112] wl[112] wl[113] wl_n[114] wl[114]
+ wl_n[115] wl_n[116] wl[115] wl[116] wl_n[117] wl_n[118] wl[117] wl[118]
+ wl_n[119] wl[119] wl_n[120] wl_n[121] wl[120] wl[121] wl_n[122] wl[122]
+ wl_n[123] wl_n[124] wl[123] wl[124] wl_n[125] wl_n[126] wl[125] wl[126]
+ wl_n[127] wl[127]
X$1 vss vdd vss wl_n[0] wl[0] vdd SP6T2WLDriver_N26L400WP26L800W
X$3 vss vdd vss wl_n[1] wl[1] vdd SP6T2WLDriver_N26L400WP26L800W
X$4 vss vdd vss wl_n[2] wl[2] vdd SP6T2WLDriver_N26L400WP26L800W
X$5 vss vdd vss wl_n[3] wl[3] vdd SP6T2WLDriver_N26L400WP26L800W
X$6 vss vdd vss wl_n[4] wl[4] vdd SP6T2WLDriver_N26L400WP26L800W
X$7 vss vdd vss wl_n[5] wl[5] vdd SP6T2WLDriver_N26L400WP26L800W
X$8 vss vdd vss wl_n[6] wl[6] vdd SP6T2WLDriver_N26L400WP26L800W
X$9 vss vdd vss wl_n[7] wl[7] vdd SP6T2WLDriver_N26L400WP26L800W
X$10 vss vdd vss wl_n[8] wl[8] vdd SP6T2WLDriver_N26L400WP26L800W
X$11 vss vdd vss wl_n[9] wl[9] vdd SP6T2WLDriver_N26L400WP26L800W
X$12 vss vdd vss wl_n[10] wl[10] vdd SP6T2WLDriver_N26L400WP26L800W
X$13 vss vdd vss wl_n[11] wl[11] vdd SP6T2WLDriver_N26L400WP26L800W
X$14 vss vdd vss wl_n[12] wl[12] vdd SP6T2WLDriver_N26L400WP26L800W
X$15 vss vdd vss wl_n[13] wl[13] vdd SP6T2WLDriver_N26L400WP26L800W
X$16 vss vdd vss wl_n[14] wl[14] vdd SP6T2WLDriver_N26L400WP26L800W
X$17 vss vdd vss wl_n[15] wl[15] vdd SP6T2WLDriver_N26L400WP26L800W
X$19 vss vdd vss wl_n[16] wl[16] vdd SP6T2WLDriver_N26L400WP26L800W
X$20 vss vdd vss wl_n[17] wl[17] vdd SP6T2WLDriver_N26L400WP26L800W
X$21 vss vdd vss wl_n[18] wl[18] vdd SP6T2WLDriver_N26L400WP26L800W
X$22 vss vdd vss wl_n[19] wl[19] vdd SP6T2WLDriver_N26L400WP26L800W
X$23 vss vdd vss wl_n[20] wl[20] vdd SP6T2WLDriver_N26L400WP26L800W
X$24 vss vdd vss wl_n[21] wl[21] vdd SP6T2WLDriver_N26L400WP26L800W
X$25 vss vdd vss wl_n[22] wl[22] vdd SP6T2WLDriver_N26L400WP26L800W
X$26 vss vdd vss wl_n[23] wl[23] vdd SP6T2WLDriver_N26L400WP26L800W
X$27 vss vdd vss wl_n[24] wl[24] vdd SP6T2WLDriver_N26L400WP26L800W
X$28 vss vdd vss wl_n[25] wl[25] vdd SP6T2WLDriver_N26L400WP26L800W
X$29 vss vdd vss wl_n[26] wl[26] vdd SP6T2WLDriver_N26L400WP26L800W
X$30 vss vdd vss wl_n[27] wl[27] vdd SP6T2WLDriver_N26L400WP26L800W
X$31 vss vdd vss wl_n[28] wl[28] vdd SP6T2WLDriver_N26L400WP26L800W
X$32 vss vdd vss wl_n[29] wl[29] vdd SP6T2WLDriver_N26L400WP26L800W
X$33 vss vdd vss wl_n[30] wl[30] vdd SP6T2WLDriver_N26L400WP26L800W
X$34 vss vdd vss wl_n[31] wl[31] vdd SP6T2WLDriver_N26L400WP26L800W
X$36 vss vdd vss wl_n[32] wl[32] vdd SP6T2WLDriver_N26L400WP26L800W
X$37 vss vdd vss wl_n[33] wl[33] vdd SP6T2WLDriver_N26L400WP26L800W
X$38 vss vdd vss wl_n[34] wl[34] vdd SP6T2WLDriver_N26L400WP26L800W
X$39 vss vdd vss wl_n[35] wl[35] vdd SP6T2WLDriver_N26L400WP26L800W
X$40 vss vdd vss wl_n[36] wl[36] vdd SP6T2WLDriver_N26L400WP26L800W
X$41 vss vdd vss wl_n[37] wl[37] vdd SP6T2WLDriver_N26L400WP26L800W
X$42 vss vdd vss wl_n[38] wl[38] vdd SP6T2WLDriver_N26L400WP26L800W
X$43 vss vdd vss wl_n[39] wl[39] vdd SP6T2WLDriver_N26L400WP26L800W
X$44 vss vdd vss wl_n[40] wl[40] vdd SP6T2WLDriver_N26L400WP26L800W
X$45 vss vdd vss wl_n[41] wl[41] vdd SP6T2WLDriver_N26L400WP26L800W
X$46 vss vdd vss wl_n[42] wl[42] vdd SP6T2WLDriver_N26L400WP26L800W
X$47 vss vdd vss wl_n[43] wl[43] vdd SP6T2WLDriver_N26L400WP26L800W
X$48 vss vdd vss wl_n[44] wl[44] vdd SP6T2WLDriver_N26L400WP26L800W
X$49 vss vdd vss wl_n[45] wl[45] vdd SP6T2WLDriver_N26L400WP26L800W
X$50 vss vdd vss wl_n[46] wl[46] vdd SP6T2WLDriver_N26L400WP26L800W
X$51 vss vdd vss wl_n[47] wl[47] vdd SP6T2WLDriver_N26L400WP26L800W
X$53 vss vdd vss wl_n[48] wl[48] vdd SP6T2WLDriver_N26L400WP26L800W
X$54 vss vdd vss wl_n[49] wl[49] vdd SP6T2WLDriver_N26L400WP26L800W
X$55 vss vdd vss wl_n[50] wl[50] vdd SP6T2WLDriver_N26L400WP26L800W
X$56 vss vdd vss wl_n[51] wl[51] vdd SP6T2WLDriver_N26L400WP26L800W
X$57 vss vdd vss wl_n[52] wl[52] vdd SP6T2WLDriver_N26L400WP26L800W
X$58 vss vdd vss wl_n[53] wl[53] vdd SP6T2WLDriver_N26L400WP26L800W
X$59 vss vdd vss wl_n[54] wl[54] vdd SP6T2WLDriver_N26L400WP26L800W
X$60 vss vdd vss wl_n[55] wl[55] vdd SP6T2WLDriver_N26L400WP26L800W
X$61 vss vdd vss wl_n[56] wl[56] vdd SP6T2WLDriver_N26L400WP26L800W
X$62 vss vdd vss wl_n[57] wl[57] vdd SP6T2WLDriver_N26L400WP26L800W
X$63 vss vdd vss wl_n[58] wl[58] vdd SP6T2WLDriver_N26L400WP26L800W
X$64 vss vdd vss wl_n[59] wl[59] vdd SP6T2WLDriver_N26L400WP26L800W
X$65 vss vdd vss wl_n[60] wl[60] vdd SP6T2WLDriver_N26L400WP26L800W
X$66 vss vdd vss wl_n[61] wl[61] vdd SP6T2WLDriver_N26L400WP26L800W
X$67 vss vdd vss wl_n[62] wl[62] vdd SP6T2WLDriver_N26L400WP26L800W
X$68 vss vdd vss wl_n[63] wl[63] vdd SP6T2WLDriver_N26L400WP26L800W
X$70 vss vdd vss wl_n[64] wl[64] vdd SP6T2WLDriver_N26L400WP26L800W
X$71 vss vdd vss wl_n[65] wl[65] vdd SP6T2WLDriver_N26L400WP26L800W
X$72 vss vdd vss wl_n[66] wl[66] vdd SP6T2WLDriver_N26L400WP26L800W
X$73 vss vdd vss wl_n[67] wl[67] vdd SP6T2WLDriver_N26L400WP26L800W
X$74 vss vdd vss wl_n[68] wl[68] vdd SP6T2WLDriver_N26L400WP26L800W
X$75 vss vdd vss wl_n[69] wl[69] vdd SP6T2WLDriver_N26L400WP26L800W
X$76 vss vdd vss wl_n[70] wl[70] vdd SP6T2WLDriver_N26L400WP26L800W
X$77 vss vdd vss wl_n[71] wl[71] vdd SP6T2WLDriver_N26L400WP26L800W
X$78 vss vdd vss wl_n[72] wl[72] vdd SP6T2WLDriver_N26L400WP26L800W
X$79 vss vdd vss wl_n[73] wl[73] vdd SP6T2WLDriver_N26L400WP26L800W
X$80 vss vdd vss wl_n[74] wl[74] vdd SP6T2WLDriver_N26L400WP26L800W
X$81 vss vdd vss wl_n[75] wl[75] vdd SP6T2WLDriver_N26L400WP26L800W
X$82 vss vdd vss wl_n[76] wl[76] vdd SP6T2WLDriver_N26L400WP26L800W
X$83 vss vdd vss wl_n[77] wl[77] vdd SP6T2WLDriver_N26L400WP26L800W
X$84 vss vdd vss wl_n[78] wl[78] vdd SP6T2WLDriver_N26L400WP26L800W
X$85 vss vdd vss wl_n[79] wl[79] vdd SP6T2WLDriver_N26L400WP26L800W
X$87 vss vdd vss wl_n[80] wl[80] vdd SP6T2WLDriver_N26L400WP26L800W
X$88 vss vdd vss wl_n[81] wl[81] vdd SP6T2WLDriver_N26L400WP26L800W
X$89 vss vdd vss wl_n[82] wl[82] vdd SP6T2WLDriver_N26L400WP26L800W
X$90 vss vdd vss wl_n[83] wl[83] vdd SP6T2WLDriver_N26L400WP26L800W
X$91 vss vdd vss wl_n[84] wl[84] vdd SP6T2WLDriver_N26L400WP26L800W
X$92 vss vdd vss wl_n[85] wl[85] vdd SP6T2WLDriver_N26L400WP26L800W
X$93 vss vdd vss wl_n[86] wl[86] vdd SP6T2WLDriver_N26L400WP26L800W
X$94 vss vdd vss wl_n[87] wl[87] vdd SP6T2WLDriver_N26L400WP26L800W
X$95 vss vdd vss wl_n[88] wl[88] vdd SP6T2WLDriver_N26L400WP26L800W
X$96 vss vdd vss wl_n[89] wl[89] vdd SP6T2WLDriver_N26L400WP26L800W
X$97 vss vdd vss wl_n[90] wl[90] vdd SP6T2WLDriver_N26L400WP26L800W
X$98 vss vdd vss wl_n[91] wl[91] vdd SP6T2WLDriver_N26L400WP26L800W
X$99 vss vdd vss wl_n[92] wl[92] vdd SP6T2WLDriver_N26L400WP26L800W
X$100 vss vdd vss wl_n[93] wl[93] vdd SP6T2WLDriver_N26L400WP26L800W
X$101 vss vdd vss wl_n[94] wl[94] vdd SP6T2WLDriver_N26L400WP26L800W
X$102 vss vdd vss wl_n[95] wl[95] vdd SP6T2WLDriver_N26L400WP26L800W
X$104 vss vdd vss wl_n[96] wl[96] vdd SP6T2WLDriver_N26L400WP26L800W
X$105 vss vdd vss wl_n[97] wl[97] vdd SP6T2WLDriver_N26L400WP26L800W
X$106 vss vdd vss wl_n[98] wl[98] vdd SP6T2WLDriver_N26L400WP26L800W
X$107 vss vdd vss wl_n[99] wl[99] vdd SP6T2WLDriver_N26L400WP26L800W
X$108 vss vdd vss wl_n[100] wl[100] vdd SP6T2WLDriver_N26L400WP26L800W
X$109 vss vdd vss wl_n[101] wl[101] vdd SP6T2WLDriver_N26L400WP26L800W
X$110 vss vdd vss wl_n[102] wl[102] vdd SP6T2WLDriver_N26L400WP26L800W
X$111 vss vdd vss wl_n[103] wl[103] vdd SP6T2WLDriver_N26L400WP26L800W
X$112 vss vdd vss wl_n[104] wl[104] vdd SP6T2WLDriver_N26L400WP26L800W
X$113 vss vdd vss wl_n[105] wl[105] vdd SP6T2WLDriver_N26L400WP26L800W
X$114 vss vdd vss wl_n[106] wl[106] vdd SP6T2WLDriver_N26L400WP26L800W
X$115 vss vdd vss wl_n[107] wl[107] vdd SP6T2WLDriver_N26L400WP26L800W
X$116 vss vdd vss wl_n[108] wl[108] vdd SP6T2WLDriver_N26L400WP26L800W
X$117 vss vdd vss wl_n[109] wl[109] vdd SP6T2WLDriver_N26L400WP26L800W
X$118 vss vdd vss wl_n[110] wl[110] vdd SP6T2WLDriver_N26L400WP26L800W
X$119 vss vdd vss wl_n[111] wl[111] vdd SP6T2WLDriver_N26L400WP26L800W
X$121 vss vdd vss wl_n[112] wl[112] vdd SP6T2WLDriver_N26L400WP26L800W
X$122 vss vdd vss wl_n[113] wl[113] vdd SP6T2WLDriver_N26L400WP26L800W
X$123 vss vdd vss wl_n[114] wl[114] vdd SP6T2WLDriver_N26L400WP26L800W
X$124 vss vdd vss wl_n[115] wl[115] vdd SP6T2WLDriver_N26L400WP26L800W
X$125 vss vdd vss wl_n[116] wl[116] vdd SP6T2WLDriver_N26L400WP26L800W
X$126 vss vdd vss wl_n[117] wl[117] vdd SP6T2WLDriver_N26L400WP26L800W
X$127 vss vdd vss wl_n[118] wl[118] vdd SP6T2WLDriver_N26L400WP26L800W
X$128 vss vdd vss wl_n[119] wl[119] vdd SP6T2WLDriver_N26L400WP26L800W
X$129 vss vdd vss wl_n[120] wl[120] vdd SP6T2WLDriver_N26L400WP26L800W
X$130 vss vdd vss wl_n[121] wl[121] vdd SP6T2WLDriver_N26L400WP26L800W
X$131 vss vdd vss wl_n[122] wl[122] vdd SP6T2WLDriver_N26L400WP26L800W
X$132 vss vdd vss wl_n[123] wl[123] vdd SP6T2WLDriver_N26L400WP26L800W
X$133 vss vdd vss wl_n[124] wl[124] vdd SP6T2WLDriver_N26L400WP26L800W
X$134 vss vdd vss wl_n[125] wl[125] vdd SP6T2WLDriver_N26L400WP26L800W
X$135 vss vdd vss wl_n[126] wl[126] vdd SP6T2WLDriver_N26L400WP26L800W
X$136 vss vdd vss wl_n[127] wl[127] vdd SP6T2WLDriver_N26L400WP26L800W
.ENDS SP6T2WLDriverCol_128RN26L400WP26L800W

.SUBCKT SP6T2RowPeriph_PD3B4B_LD2B2R vss a[0] mux[0] vdd decodeclk mux[1] a[1]
+ mux[2] mux[3] a[2] wl_n[0] wl_n[1] wl_n[2] wl_n[3] wl_n[4] wl_n[5] wl_n[6]
+ wl_n[7] wl_n[8] wl_n[9] a[3] wl_n[10] wl_n[12] wl_n[11] wl_n[14] wl_n[13]
+ wl_n[15] wl_n[16] wl_n[17] a[4] wl_n[18] wl_n[20] wl_n[19] wl_n[22] wl_n[21]
+ wl_n[23] wl_n[24] wl_n[25] a[5] wl_n[26] wl_n[27] wl_n[28] wl_n[29] wl_n[30]
+ wl_n[31] wl_n[32] wl_n[33] a[6] wl_n[34] wl_n[35] wl_n[36] wl_n[37] wl_n[38]
+ wl_n[39] wl_n[40] wl_n[41] wl_n[42] wl_n[43] a[7] wl_n[44] wl_n[45] wl_n[46]
+ wl_n[47] wl_n[48] wl_n[49] wl_n[50] wl_n[51] a[8] wl_n[52] wl_n[53] wl_n[54]
+ wl_n[55] wl_n[56] wl_n[57] wl_n[58] wl_n[59] wl_n[60] wl_n[61] wl_n[62]
+ wl_n[63] wl_n[64] wl_en wl_n[66] wl_n[65] wl_n[67] wl_n[68] wl_n[69] wl_n[70]
+ wl_n[71] wl_n[72] wl_n[73] wl_n[74] wl_n[75] wl_n[76] wl_n[77] wl_n[78]
+ wl_n[79] wl_n[80] wl_n[81] wl_n[82] wl_n[83] wl_n[84] wl_n[85] wl_n[86]
+ wl_n[87] wl_n[88] wl_n[89] wl_n[90] wl_n[91] wl_n[92] wl_n[93] wl_n[94]
+ wl_n[95] wl_n[96] wl_n[97] wl_n[98] wl_n[99] wl_n[100] wl_n[101] wl_n[102]
+ wl_n[103] wl_n[104] wl_n[105] wl_n[106] wl_n[107] wl_n[108] wl_n[109]
+ wl_n[110] wl_n[111] wl_n[112] wl_n[113] wl_n[114] wl_n[115] wl_n[116]
+ wl_n[117] wl_n[118] wl_n[119] wl_n[120] wl_n[121] wl_n[122] wl_n[123]
+ wl_n[124] wl_n[125] wl_n[126] wl_n[127]
X$1 vss vdd a[0] a[1] mux[0] mux[1] mux[2] mux[3] decodeclk
+ SP6T2DirectColDec_A2B2R
X$2 vss a[2] wl_n[0] vdd wl_n[1] wl_n[2] wl_n[4] wl_n[3] wl_n[6] wl_n[5] a[3]
+ wl_n[8] wl_n[9] wl_n[7] wl_n[10] wl_n[11] wl_n[12] wl_n[13] wl_n[14] wl_n[15]
+ a[4] wl_n[16] wl_n[17] wl_n[18] wl_n[19] wl_n[20] wl_n[21] wl_n[22] wl_n[23]
+ decodeclk wl_n[24] wl_n[25] a[5] wl_n[26] wl_n[27] wl_n[28] wl_n[29] wl_n[30]
+ wl_n[31] wl_n[32] wl_n[33] a[6] wl_n[34] wl_n[35] wl_n[36] wl_n[37] wl_n[38]
+ wl_n[39] wl_n[42] wl_n[40] wl_n[41] wl_n[43] a[7] wl_n[44] wl_n[46] wl_n[45]
+ wl_n[47] wl_n[48] wl_n[50] wl_n[49] a[8] wl_n[51] wl_n[54] wl_n[52] wl_n[53]
+ wl_n[55] wl_n[56] wl_n[57] wl_n[58] wl_n[59] wl_n[60] wl_n[61] wl_n[62]
+ wl_n[63] wl_n[64] wl_en wl_n[66] wl_n[67] wl_n[65] wl_n[68] wl_n[69] wl_n[70]
+ wl_n[71] wl_n[72] wl_n[73] wl_n[74] wl_n[75] wl_n[76] wl_n[77] wl_n[78]
+ wl_n[79] wl_n[82] wl_n[80] wl_n[81] wl_n[84] wl_n[85] wl_n[83] wl_n[86]
+ wl_n[87] wl_n[88] wl_n[90] wl_n[89] wl_n[92] wl_n[91] wl_n[93] wl_n[94]
+ wl_n[95] wl_n[98] wl_n[96] wl_n[97] wl_n[100] wl_n[99] wl_n[101] wl_n[102]
+ wl_n[103] wl_n[104] wl_n[106] wl_n[105] wl_n[108] wl_n[107] wl_n[109]
+ wl_n[110] wl_n[111] wl_n[112] wl_n[114] wl_n[113] wl_n[116] wl_n[115]
+ wl_n[117] wl_n[118] wl_n[119] wl_n[120] wl_n[122] wl_n[121] wl_n[124]
+ wl_n[125] wl_n[123] wl_n[126] wl_n[127] SP6T2RowDec_PD3B4B_PAG3B4B0
.ENDS SP6T2RowPeriph_PD3B4B_LD2B2R

.SUBCKT SP6T2NonOvlClock_4S11341D1R vss vdd firststage[3] secondstage[3] clk
X$1 vss vdd secondstage[4] secondstage[3] inv_x0
X$2 vss vdd secondstage[3] secondstage[2] inv_x0
X$3 vss vdd secondstage[2] secondstage[1] inv_x0
X$4 vss vdd secondstage[1] secondstage[0] inv_x0
X$5 vss vdd \$15 secondstage[0] firststage[4] nand2_x0
X$6 vss vdd \$15 clk inv_x0
X$7 vss vdd clk firststage[0] secondstage[4] nand2_x0
X$8 vss vdd firststage[1] firststage[0] inv_x0
X$9 vss vdd firststage[2] firststage[1] inv_x0
X$10 vss vdd firststage[3] firststage[2] inv_x0
X$11 vss vdd firststage[4] firststage[3] inv_x0
.ENDS SP6T2NonOvlClock_4S11341D1R

.SUBCKT Delay_buf_x1 vdd vss i q
M$1 \$1 i vss vss sg13_lv_nmos L=0.25u W=0.78u AS=0.2652p AD=0.2092p PS=2.24u
+ PD=1.48u
M$2 vss \$1 q vss sg13_lv_nmos L=0.25u W=1.07u AS=0.2092p AD=0.3638p PS=1.48u
+ PD=2.82u
M$3 vdd i \$1 vdd sg13_lv_pmos L=0.25u W=0.78u AS=0.2075p AD=0.2652p PS=1.47u
+ PD=2.24u
M$4 vdd \$1 q vdd sg13_lv_pmos L=0.25u W=1.06u AS=0.2075p AD=0.3604p PS=1.47u
+ PD=2.8u
.ENDS Delay_buf_x1

.SUBCKT inv_x3 vss vdd nq i
M$1 vss i nq vss sg13_lv_nmos L=0.13u W=4.38u AS=1.0512p AD=1.0512p PS=7.28u
+ PD=7.28u
M$4 vdd i nq vdd sg13_lv_pmos L=0.13u W=4.35u AS=1.044p AD=1.044p PS=7.24u
+ PD=7.24u
.ENDS inv_x3

.SUBCKT buf_x4 vdd vss i q
M$1 \$1 i vss vss sg13_lv_nmos L=0.13u W=1.07u AS=0.3638p AD=0.214p PS=2.82u
+ PD=1.47u
M$2 vss \$1 q vss sg13_lv_nmos L=0.13u W=4.28u AS=0.8239p AD=0.9737p PS=5.82u
+ PD=7.17u
M$6 \$1 i vdd vdd sg13_lv_pmos L=0.13u W=1.06u AS=0.3604p AD=0.212p PS=2.8u
+ PD=1.46u
M$7 vdd \$1 q vdd sg13_lv_pmos L=0.13u W=4.24u AS=0.8162p AD=0.9646p PS=5.78u
+ PD=7.12u
.ENDS buf_x4

.SUBCKT buf_x1 vdd vss i q
M$1 \$1 i vss vss sg13_lv_nmos L=0.13u W=0.78u AS=0.2652p AD=0.2092p PS=2.24u
+ PD=1.48u
M$2 vss \$1 q vss sg13_lv_nmos L=0.13u W=1.07u AS=0.2092p AD=0.3638p PS=1.48u
+ PD=2.82u
M$3 vdd i \$1 vdd sg13_lv_pmos L=0.13u W=0.78u AS=0.2075p AD=0.2652p PS=1.47u
+ PD=2.24u
M$4 vdd \$1 q vdd sg13_lv_pmos L=0.13u W=1.06u AS=0.2075p AD=0.3604p PS=1.47u
+ PD=2.8u
.ENDS buf_x1

.SUBCKT SP6T2Column_128R_CP8B_CM4MN26L580W1R_PC26L100W vss d[0] q[0] d[1] q[1]
+ d[2] q[2] d[3] q[3] d[4] q[4] d[5] q[5] d[6] q[6] d[7] q[7] we clk we_en
+ mux[0] vdd mux[2] mux[3] mux[1] wl[2] precharge_n wl[0] wl[1] wl[8] wl[11]
+ wl[10] wl[3] wl[4] wl[5] wl[6] wl[7] wl[9] wl[12] wl[22] wl[20] wl[19] wl[21]
+ wl[23] wl[18] wl[24] wl[25] wl[17] wl[26] wl[27] wl[15] wl[14] wl[13] wl[16]
+ wl[40] wl[39] wl[38] wl[37] wl[36] wl[35] wl[28] wl[34] wl[33] wl[32] wl[42]
+ wl[43] wl[29] wl[30] wl[31] wl[41] wl[59] wl[54] wl[49] wl[58] wl[50] wl[57]
+ wl[51] wl[56] wl[52] wl[55] wl[53] wl[47] wl[46] wl[45] wl[44] wl[48] wl[67]
+ wl[68] wl[66] wl[69] wl[70] wl[71] wl[65] wl[72] wl[75] wl[73] wl[64] wl[74]
+ wl[60] wl[61] wl[63] wl[62] wl[91] wl[86] wl[81] wl[90] wl[89] wl[82] wl[88]
+ wl[83] wl[84] wl[87] wl[85] wl[79] wl[78] wl[77] wl[76] wl[80] wl[99] wl[100]
+ wl[98] wl[101] wl[102] wl[103] wl[97] wl[104] wl[107] wl[105] wl[96] wl[106]
+ wl[92] wl[93] wl[95] wl[94] wl[123] wl[118] wl[113] wl[122] wl[121] wl[114]
+ wl[120] wl[115] wl[116] wl[119] wl[117] wl[111] wl[110] wl[109] wl[108]
+ wl[112] wl[127] wl[126] wl[125] wl[124]
X$1 vss we d[0] d[1] vdd d[2] d[3] d[4] d[5] d[6] d[7] clk we_en q[0] q[1] q[2]
+ q[3] q[4] q[5] q[6] q[7] mux[0] \$57 \$56 \$54 \$53 \$51 \$50 \$48 \$47 \$44
+ \$74 \$73 \$72 \$71 \$70 \$69 \$68 \$66 \$65 \$63 \$62 \$60 \$59 \$84 \$83
+ \$82 \$81 \$80 \$79 \$78 \$77 \$76 \$75 mux[3] precharge_n mux[2] mux[1] \$98
+ \$99 \$100 \$101 \$102 \$103 \$104 \$105 \$107 \$106 \$97 \$96 \$95 \$94 \$93
+ \$92 \$91 \$90 \$89 \$88 \$87 \$86 \$85 \$67 \$64 \$61 \$58 \$55 \$52 \$49
+ \$46 \$45 vdd SP6T2ColPeriph8B_PC26L100W_CM4MN26L580W1R
X$2 vss wl[20] wl[15] wl[18] wl[17] vdd wl[16] wl[28] wl[32] wl[34] wl[35]
+ wl[36] wl[31] wl[37] wl[30] wl[38] wl[29] wl[39] wl[19] wl[40] wl[27] wl[41]
+ wl[26] wl[25] wl[42] wl[24] wl[23] wl[22] wl[21] wl[33] wl[13] wl[14] wl[0]
+ wl[1] wl[2] wl[3] wl[4] wl[5] wl[6] wl[7] wl[8] wl[9] wl[10] wl[11] wl[12]
+ \$57 \$56 \$54 \$53 \$51 \$50 \$48 \$47 \$44 \$74 \$73 \$72 \$71 \$70 \$69
+ \$68 \$66 \$65 \$63 \$62 \$60 \$59 \$84 \$83 \$82 \$81 \$80 \$79 \$78 \$77
+ \$76 \$75 wl[60] wl[43] wl[58] wl[57] wl[44] wl[56] wl[55] wl[45] wl[54]
+ wl[59] wl[53] wl[63] wl[52] wl[51] wl[50] wl[46] wl[49] wl[61] wl[48] wl[62]
+ wl[47] \$98 \$99 \$100 \$101 \$102 \$103 \$104 \$105 \$107 \$106 \$97 \$96
+ \$95 \$94 \$93 \$92 \$91 \$90 \$89 \$88 \$87 \$86 \$85 \$67 \$64 \$61 \$58
+ \$55 \$52 \$49 \$46 \$45 wl[122] wl[121] wl[88] wl[107] wl[108] wl[87]
+ wl[109] wl[120] wl[110] wl[86] wl[111] wl[106] wl[85] wl[119] wl[112] wl[113]
+ wl[84] wl[118] wl[114] wl[115] wl[83] wl[117] wl[116] wl[100] wl[96] wl[95]
+ wl[94] wl[127] wl[97] wl[93] wl[98] wl[126] wl[99] wl[92] wl[125] wl[101]
+ wl[91] wl[102] wl[124] wl[103] wl[90] wl[104] wl[123] wl[105] wl[89] wl[81]
+ wl[82] wl[64] wl[65] wl[66] wl[67] wl[68] wl[69] wl[70] wl[71] wl[72] wl[73]
+ wl[74] wl[75] wl[76] wl[77] wl[78] wl[79] wl[80] SP6T2Array_128X32BC
.ENDS SP6T2Column_128R_CP8B_CM4MN26L580W1R_PC26L100W

.SUBCKT SP6T2WLDriver_N26L400WP26L800W \$1 vdd vss wl_n wl_drive nwell
M$1 vss wl_n wl_drive \$1 sg13_lv_nmos L=0.13u W=4u AS=1.11p AD=1.11p PS=7.11u
+ PD=7.11u
M$3 vdd wl_n wl_drive nwell sg13_lv_pmos L=0.13u W=8u AS=2.22p AD=2.22p
+ PS=13.11u PD=13.11u
.ENDS SP6T2WLDriver_N26L400WP26L800W

.SUBCKT SP6T2RowDec_PD3B4B_PAG3B4B0 vss a[0] wl_n[0] vdd wl_n[1] wl_n[2]
+ wl_n[4] wl_n[3] wl_n[6] wl_n[5] a[1] wl_n[8] wl_n[9] wl_n[7] wl_n[10]
+ wl_n[11] wl_n[12] wl_n[13] wl_n[14] wl_n[15] a[2] wl_n[16] wl_n[17] wl_n[18]
+ wl_n[19] wl_n[20] wl_n[21] wl_n[22] wl_n[23] clk wl_n[24] wl_n[25] a[3]
+ wl_n[26] wl_n[27] wl_n[28] wl_n[29] wl_n[30] wl_n[31] wl_n[32] wl_n[33] a[4]
+ wl_n[34] wl_n[35] wl_n[36] wl_n[37] wl_n[38] wl_n[39] wl_n[42] wl_n[40]
+ wl_n[41] wl_n[43] a[5] wl_n[44] wl_n[46] wl_n[45] wl_n[47] wl_n[48] wl_n[50]
+ wl_n[49] a[6] wl_n[51] wl_n[54] wl_n[52] wl_n[53] wl_n[55] wl_n[56] wl_n[57]
+ wl_n[58] wl_n[59] wl_n[60] wl_n[61] wl_n[62] wl_n[63] wl_n[64] wl_en wl_n[66]
+ wl_n[67] wl_n[65] wl_n[68] wl_n[69] wl_n[70] wl_n[71] wl_n[72] wl_n[73]
+ wl_n[74] wl_n[75] wl_n[76] wl_n[77] wl_n[78] wl_n[79] wl_n[82] wl_n[80]
+ wl_n[81] wl_n[84] wl_n[85] wl_n[83] wl_n[86] wl_n[87] wl_n[88] wl_n[90]
+ wl_n[89] wl_n[92] wl_n[91] wl_n[93] wl_n[94] wl_n[95] wl_n[98] wl_n[96]
+ wl_n[97] wl_n[100] wl_n[99] wl_n[101] wl_n[102] wl_n[103] wl_n[104] wl_n[106]
+ wl_n[105] wl_n[108] wl_n[107] wl_n[109] wl_n[110] wl_n[111] wl_n[112]
+ wl_n[114] wl_n[113] wl_n[116] wl_n[115] wl_n[117] wl_n[118] wl_n[119]
+ wl_n[120] wl_n[122] wl_n[121] wl_n[124] wl_n[125] wl_n[123] wl_n[126]
+ wl_n[127]
X$1 vdd vss \$6 \$13 \$4 \$9 \$31 \$10 \$17 \$45 \$12 \$58 \$18 \$19 \$72 \$88
+ \$101 \$116 \$132 \$145 \$156 \$163 \$174 \$185 \$196 \$211 clk a[0] a[1]
+ a[2] a[3] a[4] a[5] a[6] SP6T2RowPredecoders_A3B4B
X$3 vss wl_n[0] \$4 \$6 wl_n[1] vdd wl_n[2] \$10 \$9 wl_n[3] wl_n[4] wl_en \$12
+ \$17 wl_n[5] wl_n[6] \$19 \$18 wl_n[7] \$13 SP6T2RowDecPage_PD3B4BDH
X$4 vss wl_n[8] \$4 \$6 wl_n[9] vdd wl_n[10] \$10 \$9 wl_n[11] wl_n[12] wl_en
+ \$12 \$17 wl_n[13] wl_n[14] \$19 \$18 wl_n[15] \$31 SP6T2RowDecPage_PD3B4BDH
X$6 vss wl_n[16] \$4 \$6 wl_n[17] vdd wl_n[18] \$10 \$9 wl_n[19] wl_n[20] wl_en
+ \$12 \$17 wl_n[21] wl_n[22] \$19 \$18 wl_n[23] \$45 SP6T2RowDecPage_PD3B4BDH
X$7 vss wl_n[24] \$4 \$6 wl_n[25] vdd wl_n[26] \$10 \$9 wl_n[27] wl_n[28] wl_en
+ \$12 \$17 wl_n[29] wl_n[30] \$19 \$18 wl_n[31] \$58 SP6T2RowDecPage_PD3B4BDH
X$9 vss wl_n[32] \$4 \$6 wl_n[33] vdd wl_n[34] \$10 \$9 wl_n[35] wl_n[36] wl_en
+ \$12 \$17 wl_n[37] wl_n[38] \$19 \$18 wl_n[39] \$72 SP6T2RowDecPage_PD3B4BDH
X$10 vss wl_n[40] \$4 \$6 wl_n[41] vdd wl_n[42] \$10 \$9 wl_n[43] wl_n[44]
+ wl_en \$12 \$17 wl_n[45] wl_n[46] \$19 \$18 wl_n[47] \$88
+ SP6T2RowDecPage_PD3B4BDH
X$12 vss wl_n[48] \$4 \$6 wl_n[49] vdd wl_n[50] \$10 \$9 wl_n[51] wl_n[52]
+ wl_en \$12 \$17 wl_n[53] wl_n[54] \$19 \$18 wl_n[55] \$101
+ SP6T2RowDecPage_PD3B4BDH
X$13 vss wl_n[56] \$4 \$6 wl_n[57] vdd wl_n[58] \$10 \$9 wl_n[59] wl_n[60]
+ wl_en \$12 \$17 wl_n[61] wl_n[62] \$19 \$18 wl_n[63] \$116
+ SP6T2RowDecPage_PD3B4BDH
X$15 vss wl_n[64] \$4 \$6 wl_n[65] vdd wl_n[66] \$10 \$9 wl_n[67] wl_n[68]
+ wl_en \$12 \$17 wl_n[69] wl_n[70] \$19 \$18 wl_n[71] \$132
+ SP6T2RowDecPage_PD3B4BDH
X$16 vss wl_n[72] \$4 \$6 wl_n[73] vdd wl_n[74] \$10 \$9 wl_n[75] wl_n[76]
+ wl_en \$12 \$17 wl_n[77] wl_n[78] \$19 \$18 wl_n[79] \$145
+ SP6T2RowDecPage_PD3B4BDH
X$18 vss wl_n[80] \$4 \$6 wl_n[81] vdd wl_n[82] \$10 \$9 wl_n[83] wl_n[84]
+ wl_en \$12 \$17 wl_n[85] wl_n[86] \$19 \$18 wl_n[87] \$156
+ SP6T2RowDecPage_PD3B4BDH
X$19 vss wl_n[88] \$4 \$6 wl_n[89] vdd wl_n[90] \$10 \$9 wl_n[91] wl_n[92]
+ wl_en \$12 \$17 wl_n[93] wl_n[94] \$19 \$18 wl_n[95] \$163
+ SP6T2RowDecPage_PD3B4BDH
X$21 vss wl_n[96] \$4 \$6 wl_n[97] vdd wl_n[98] \$10 \$9 wl_n[99] wl_n[100]
+ wl_en \$12 \$17 wl_n[101] wl_n[102] \$19 \$18 wl_n[103] \$174
+ SP6T2RowDecPage_PD3B4BDH
X$22 vss wl_n[104] \$4 \$6 wl_n[105] vdd wl_n[106] \$10 \$9 wl_n[107] wl_n[108]
+ wl_en \$12 \$17 wl_n[109] wl_n[110] \$19 \$18 wl_n[111] \$185
+ SP6T2RowDecPage_PD3B4BDH
X$24 vss wl_n[112] \$4 \$6 wl_n[113] vdd wl_n[114] \$10 \$9 wl_n[115] wl_n[116]
+ wl_en \$12 \$17 wl_n[117] wl_n[118] \$19 \$18 wl_n[119] \$196
+ SP6T2RowDecPage_PD3B4BDH
X$25 vss wl_n[120] \$4 \$6 wl_n[121] vdd wl_n[122] \$10 \$9 wl_n[123] wl_n[124]
+ wl_en \$12 \$17 wl_n[125] wl_n[126] \$19 \$18 wl_n[127] \$211
+ SP6T2RowDecPage_PD3B4BDH
.ENDS SP6T2RowDec_PD3B4B_PAG3B4B0

.SUBCKT SP6T2DirectColDec_A2B2R vss vdd a[0] a[1] line[0] line[1] line[2]
+ line[3] clk
X$1 vss a[0] \$11 clk vdd SP6T1Dec_dff_x1
X$2 vss a[1] \$12 clk vdd SP6T1Dec_dff_x1
X$3 vss vdd \$13 \$11 SP6T1Dec_inv_x1
X$4 vss vdd \$13 \$16 \$14 SP6T1Dec_nand2_x0
X$5 vss vdd line[0] \$16 SP6T1Dec_inv_x2
X$6 vss vdd \$11 \$17 \$14 SP6T1Dec_nand2_x0
X$7 vss vdd line[1] \$17 SP6T1Dec_inv_x2
X$8 vss vdd \$13 \$18 \$12 SP6T1Dec_nand2_x0
X$9 vss vdd \$14 \$12 SP6T1Dec_inv_x1
X$10 vss vdd line[2] \$18 SP6T1Dec_inv_x2
X$11 vss vdd \$11 \$19 \$12 SP6T1Dec_nand2_x0
X$12 vss vdd line[3] \$19 SP6T1Dec_inv_x2
.ENDS SP6T2DirectColDec_A2B2R

.SUBCKT SP6T2Array_128X32BC vss wl[20] wl[15] wl[18] wl[17] vdd wl[16] wl[28]
+ wl[32] wl[34] wl[35] wl[36] wl[31] wl[37] wl[30] wl[38] wl[29] wl[39] wl[19]
+ wl[40] wl[27] wl[41] wl[26] wl[25] wl[42] wl[24] wl[23] wl[22] wl[21] wl[33]
+ wl[13] wl[14] wl[0] wl[1] wl[2] wl[3] wl[4] wl[5] wl[6] wl[7] wl[8] wl[9]
+ wl[10] wl[11] wl[12] bl[0] bl_n[0] bl_n[1] bl[1] bl[2] bl_n[2] bl_n[3] bl[3]
+ bl[4] bl_n[4] bl_n[5] bl[5] bl[6] bl_n[6] bl_n[7] bl[7] bl[8] bl_n[8] bl_n[9]
+ bl[9] bl[10] bl_n[10] bl_n[11] bl[11] bl[12] bl_n[12] bl_n[13] bl[13] bl[14]
+ bl_n[14] bl_n[15] bl[15] wl[60] wl[43] wl[58] wl[57] wl[44] wl[56] wl[55]
+ wl[45] wl[54] wl[59] wl[53] wl[63] wl[52] wl[51] wl[50] wl[46] wl[49] wl[61]
+ wl[48] wl[62] wl[47] bl[16] bl_n[16] bl_n[17] bl[17] bl[18] bl_n[18] bl_n[19]
+ bl[19] bl[20] bl_n[20] bl_n[21] bl[21] bl[22] bl_n[22] bl_n[23] bl[23] bl[24]
+ bl_n[24] bl_n[25] bl[25] bl[26] bl_n[26] bl_n[27] bl[27] bl[28] bl_n[28]
+ bl_n[29] bl[29] bl[30] bl_n[30] bl_n[31] bl[31] wl[122] wl[121] wl[88]
+ wl[107] wl[108] wl[87] wl[109] wl[120] wl[110] wl[86] wl[111] wl[106] wl[85]
+ wl[119] wl[112] wl[113] wl[84] wl[118] wl[114] wl[115] wl[83] wl[117] wl[116]
+ wl[100] wl[96] wl[95] wl[94] wl[127] wl[97] wl[93] wl[98] wl[126] wl[99]
+ wl[92] wl[125] wl[101] wl[91] wl[102] wl[124] wl[103] wl[90] wl[104] wl[123]
+ wl[105] wl[89] wl[81] wl[82] wl[64] wl[65] wl[66] wl[67] wl[68] wl[69] wl[70]
+ wl[71] wl[72] wl[73] wl[74] wl[75] wl[76] wl[77] wl[78] wl[79] wl[80]
X$2 vss bl[0] bl_n[0] bl_n[1] bl[1] bl[2] bl_n[2] bl_n[3] bl[3] bl[4] bl_n[4]
+ bl_n[5] bl[5] bl[6] bl_n[6] bl_n[7] bl[7] bl[8] bl_n[8] bl_n[9] bl[9] bl[10]
+ bl_n[10] bl_n[11] bl[11] bl[12] bl_n[12] bl_n[13] bl[13] bl[14] bl_n[14]
+ bl_n[15] bl[15] wl[26] wl[16] wl[31] wl[30] wl[29] wl[28] wl[17] wl[27]
+ wl[20] wl[18] wl[25] wl[24] wl[23] wl[19] wl[22] wl[21] vdd wl[0] wl[1] wl[2]
+ wl[3] wl[4] wl[5] wl[6] wl[7] wl[8] wl[9] wl[10] wl[11] wl[12] wl[13] wl[14]
+ wl[15] bl[16] bl_n[16] bl_n[17] bl[17] bl[18] bl_n[18] bl_n[19] bl[19] bl[20]
+ bl_n[20] bl_n[21] bl[21] bl[22] bl_n[22] bl_n[23] bl[23] bl[24] bl_n[24]
+ bl_n[25] bl[25] bl[26] bl_n[26] bl_n[27] bl[27] bl[28] bl_n[28] bl_n[29]
+ bl[29] bl[30] bl_n[30] bl_n[31] bl[31] wl[50] wl[32] wl[51] wl[52] wl[53]
+ wl[54] wl[55] wl[56] wl[57] wl[58] wl[59] wl[60] wl[61] wl[62] wl[47] wl[41]
+ wl[43] wl[40] wl[44] wl[39] wl[45] wl[38] wl[46] wl[37] wl[42] wl[36] wl[35]
+ wl[34] wl[48] wl[33] wl[49] wl[63] SP6T2Array_64X32
X$4 vss bl[0] bl_n[0] bl_n[1] bl[1] bl[2] bl_n[2] bl_n[3] bl[3] bl[4] bl_n[4]
+ bl_n[5] bl[5] bl[6] bl_n[6] bl_n[7] bl[7] bl[8] bl_n[8] bl_n[9] bl[9] bl[10]
+ bl_n[10] bl_n[11] bl[11] bl[12] bl_n[12] bl_n[13] bl[13] bl[14] bl_n[14]
+ bl_n[15] bl[15] wl[90] wl[80] wl[95] wl[94] wl[93] wl[92] wl[81] wl[91]
+ wl[84] wl[82] wl[89] wl[88] wl[87] wl[83] wl[86] wl[85] vdd wl[64] wl[65]
+ wl[66] wl[67] wl[68] wl[69] wl[70] wl[71] wl[72] wl[73] wl[74] wl[75] wl[76]
+ wl[77] wl[78] wl[79] bl[16] bl_n[16] bl_n[17] bl[17] bl[18] bl_n[18] bl_n[19]
+ bl[19] bl[20] bl_n[20] bl_n[21] bl[21] bl[22] bl_n[22] bl_n[23] bl[23] bl[24]
+ bl_n[24] bl_n[25] bl[25] bl[26] bl_n[26] bl_n[27] bl[27] bl[28] bl_n[28]
+ bl_n[29] bl[29] bl[30] bl_n[30] bl_n[31] bl[31] wl[114] wl[96] wl[115]
+ wl[116] wl[117] wl[118] wl[119] wl[120] wl[121] wl[122] wl[123] wl[124]
+ wl[125] wl[126] wl[111] wl[105] wl[107] wl[104] wl[108] wl[103] wl[109]
+ wl[102] wl[110] wl[101] wl[106] wl[100] wl[99] wl[98] wl[112] wl[97] wl[113]
+ wl[127] SP6T2Array_64X32
.ENDS SP6T2Array_128X32BC

.SUBCKT SP6T2ColPeriph8B_PC26L100W_CM4MN26L580W1R vss we d[0] d[1] vdd d[2]
+ d[3] d[4] d[5] d[6] d[7] clk we_en q[0] q[1] q[2] q[3] q[4] q[5] q[6] q[7]
+ mux[0] bl[0] bl_n[0] bl_n[1] bl[1] bl[2] bl_n[2] bl_n[3] bl[3] bl[4] bl_n[4]
+ bl_n[5] bl[5] bl[6] bl_n[6] bl_n[7] bl[7] bl[8] bl_n[8] bl_n[9] bl[9] bl[10]
+ bl_n[10] bl_n[11] bl[11] bl[12] bl_n[12] bl_n[13] bl[13] bl[14] bl_n[14]
+ bl_n[15] bl[15] mux[3] precharge_n mux[2] mux[1] bl[16] bl_n[16] bl_n[17]
+ bl[17] bl[18] bl_n[18] bl_n[19] bl[19] bl[20] bl_n[20] bl_n[21] bl[21] bl[22]
+ bl_n[22] bl_n[23] bl[23] bl[24] bl_n[24] bl_n[25] bl[25] bl[26] bl_n[26]
+ bl_n[27] bl[27] bl[28] bl_n[28] bl_n[29] bl[29] bl[30] bl_n[30] bl_n[31]
+ bl[31] \$I302
X$1 vss \$34 bl[4] bl_n[4] \$32 bl_n[5] bl[5] bl[6] bl_n[6] bl_n[7] bl[7]
+ mux[0] mux[1] mux[2] mux[3] SP6T2ColMux_4MN26L580W1R
X$2 vss \$29 bl[0] bl_n[0] \$28 bl_n[1] bl[1] bl[2] bl_n[2] bl_n[3] bl[3]
+ mux[0] mux[1] mux[2] mux[3] SP6T2ColMux_4MN26L580W1R
X$3 precharge_n bl[0] bl_n[0] vdd \$I302 SP6T2Precharge_26L100W
X$4 precharge_n bl[1] bl_n[1] vdd \$I302 SP6T2Precharge_26L100W
X$5 precharge_n bl[2] bl_n[2] vdd \$I302 SP6T2Precharge_26L100W
X$6 precharge_n bl[3] bl_n[3] vdd \$I302 SP6T2Precharge_26L100W
X$7 precharge_n bl[4] bl_n[4] vdd \$I302 SP6T2Precharge_26L100W
X$8 vss \$39 bl[8] bl_n[8] \$37 bl_n[9] bl[9] bl[10] bl_n[10] bl_n[11] bl[11]
+ mux[0] mux[1] mux[2] mux[3] SP6T2ColMux_4MN26L580W1R
X$9 precharge_n bl[5] bl_n[5] vdd \$I302 SP6T2Precharge_26L100W
X$10 precharge_n bl[6] bl_n[6] vdd \$I302 SP6T2Precharge_26L100W
X$11 precharge_n bl[7] bl_n[7] vdd \$I302 SP6T2Precharge_26L100W
X$12 precharge_n bl[8] bl_n[8] vdd \$I302 SP6T2Precharge_26L100W
X$13 vss \$43 bl[12] bl_n[12] \$42 bl_n[13] bl[13] bl[14] bl_n[14] bl_n[15]
+ bl[15] mux[0] mux[1] mux[2] mux[3] SP6T2ColMux_4MN26L580W1R
X$14 precharge_n bl[9] bl_n[9] vdd \$I302 SP6T2Precharge_26L100W
X$15 precharge_n bl[10] bl_n[10] vdd \$I302 SP6T2Precharge_26L100W
X$16 precharge_n bl[11] bl_n[11] vdd \$I302 SP6T2Precharge_26L100W
X$17 precharge_n bl[12] bl_n[12] vdd \$I302 SP6T2Precharge_26L100W
X$18 vss \$40 bl[16] bl_n[16] \$41 bl_n[17] bl[17] bl[18] bl_n[18] bl_n[19]
+ bl[19] mux[0] mux[1] mux[2] mux[3] SP6T2ColMux_4MN26L580W1R
X$19 precharge_n bl[13] bl_n[13] vdd \$I302 SP6T2Precharge_26L100W
X$20 precharge_n bl[14] bl_n[14] vdd \$I302 SP6T2Precharge_26L100W
X$21 precharge_n bl[15] bl_n[15] vdd \$I302 SP6T2Precharge_26L100W
X$22 precharge_n bl[16] bl_n[16] vdd \$I302 SP6T2Precharge_26L100W
X$23 vss \$38 bl[20] bl_n[20] \$36 bl_n[21] bl[21] bl[22] bl_n[22] bl_n[23]
+ bl[23] mux[0] mux[1] mux[2] mux[3] SP6T2ColMux_4MN26L580W1R
X$24 precharge_n bl[17] bl_n[17] vdd \$I302 SP6T2Precharge_26L100W
X$25 precharge_n bl[18] bl_n[18] vdd \$I302 SP6T2Precharge_26L100W
X$26 precharge_n bl[19] bl_n[19] vdd \$I302 SP6T2Precharge_26L100W
X$27 precharge_n bl[20] bl_n[20] vdd \$I302 SP6T2Precharge_26L100W
X$28 vss \$35 bl[24] bl_n[24] \$33 bl_n[25] bl[25] bl[26] bl_n[26] bl_n[27]
+ bl[27] mux[0] mux[1] mux[2] mux[3] SP6T2ColMux_4MN26L580W1R
X$29 precharge_n bl[21] bl_n[21] vdd \$I302 SP6T2Precharge_26L100W
X$30 precharge_n bl[22] bl_n[22] vdd \$I302 SP6T2Precharge_26L100W
X$31 precharge_n bl[23] bl_n[23] vdd \$I302 SP6T2Precharge_26L100W
X$32 precharge_n bl[24] bl_n[24] vdd \$I302 SP6T2Precharge_26L100W
X$33 vss \$31 bl[28] bl_n[28] \$30 bl_n[29] bl[29] bl[30] bl_n[30] bl_n[31]
+ bl[31] mux[0] mux[1] mux[2] mux[3] SP6T2ColMux_4MN26L580W1R
X$34 precharge_n bl[25] bl_n[25] vdd \$I302 SP6T2Precharge_26L100W
X$35 precharge_n bl[26] bl_n[26] vdd \$I302 SP6T2Precharge_26L100W
X$36 precharge_n bl[27] bl_n[27] vdd \$I302 SP6T2Precharge_26L100W
X$37 precharge_n bl[28] bl_n[28] vdd \$I302 SP6T2Precharge_26L100W
X$38 precharge_n bl[29] bl_n[29] vdd \$I302 SP6T2Precharge_26L100W
X$39 precharge_n bl[30] bl_n[30] vdd \$I302 SP6T2Precharge_26L100W
X$40 precharge_n bl[31] bl_n[31] vdd \$I302 SP6T2Precharge_26L100W
X$41 \$29 vss \$28 vdd q[0] d[0] \$12 \$16
+ SP6T2ReadWrite_CM4MN26L580W1R_WD26L380W
X$42 \$34 vss \$32 vdd q[1] d[1] \$12 \$16
+ SP6T2ReadWrite_CM4MN26L580W1R_WD26L380W
X$43 \$39 vss \$37 vdd q[2] d[2] \$12 \$16
+ SP6T2ReadWrite_CM4MN26L580W1R_WD26L380W
X$44 \$43 vss \$42 vdd q[3] d[3] \$12 \$16
+ SP6T2ReadWrite_CM4MN26L580W1R_WD26L380W
X$45 \$40 vss \$41 vdd q[4] d[4] \$12 \$16
+ SP6T2ReadWrite_CM4MN26L580W1R_WD26L380W
X$46 \$38 vss \$36 vdd q[5] d[5] \$12 \$16
+ SP6T2ReadWrite_CM4MN26L580W1R_WD26L380W
X$47 \$35 vss \$33 vdd q[6] d[6] \$12 \$16
+ SP6T2ReadWrite_CM4MN26L580W1R_WD26L380W
X$48 clk we we_en \$16 vss vdd \$12 SP6T2ClockWE
X$49 \$31 vss \$30 vdd q[7] d[7] \$12 \$16
+ SP6T2ReadWrite_CM4MN26L580W1R_WD26L380W
.ENDS SP6T2ColPeriph8B_PC26L100W_CM4MN26L580W1R

.SUBCKT SP6T2RowDecPage_PD3B4BDH vss wl_n[0] pd[0][1] pd[0][0] wl_n[1] vdd
+ wl_n[2] pd[0][3] pd[0][2] wl_n[3] wl_n[4] wl_en pd[0][5] pd[0][4] wl_n[5]
+ wl_n[6] pd[0][7] pd[0][6] wl_n[7] page
X$1 vss vdd wl_n[2] wl_en pd[0][2] page wl_n[3] pd[0][3] SP6T2RowDecoderNand3X2
X$2 vss vdd wl_n[0] wl_en pd[0][0] page wl_n[1] pd[0][1] SP6T2RowDecoderNand3X2
X$3 vss vdd wl_n[4] wl_en pd[0][4] page wl_n[5] pd[0][5] SP6T2RowDecoderNand3X2
X$4 vss vdd wl_n[6] wl_en pd[0][6] page wl_n[7] pd[0][7] SP6T2RowDecoderNand3X2
.ENDS SP6T2RowDecPage_PD3B4BDH

.SUBCKT SP6T2RowPredecoders_A3B4B vdd vss pd[0][0] page[0] pd[0][1] pd[0][2]
+ page[1] pd[0][3] pd[0][4] page[2] pd[0][5] page[3] pd[0][6] pd[0][7] page[4]
+ page[5] page[6] page[7] page[8] page[9] page[10] page[11] page[12] page[13]
+ page[14] page[15] clk a[0] a[1] a[2] a[3] a[4] a[5] a[6]
X$1 vdd vss \$27 \$28 \$29 pd[0][0] SP6T1Dec_and3_x1
X$2 vdd vss \$30 \$31 \$32 \$33 page[0] SP6T1Dec_and4_x1
X$3 vdd vss \$34 \$28 \$29 pd[0][1] SP6T1Dec_and3_x1
X$4 vdd vss \$27 \$35 \$29 pd[0][2] SP6T1Dec_and3_x1
X$5 vdd vss \$36 \$31 \$32 \$33 page[1] SP6T1Dec_and4_x1
X$6 vdd vss \$34 \$35 \$29 pd[0][3] SP6T1Dec_and3_x1
X$7 vdd vss \$27 \$28 \$37 pd[0][4] SP6T1Dec_and3_x1
X$8 vdd vss \$30 \$38 \$32 \$33 page[2] SP6T1Dec_and4_x1
X$9 vdd vss \$34 \$28 \$37 pd[0][5] SP6T1Dec_and3_x1
X$10 vdd vss \$36 \$38 \$32 \$33 page[3] SP6T1Dec_and4_x1
X$11 vdd vss \$27 \$35 \$37 pd[0][6] SP6T1Dec_and3_x1
X$12 vdd vss \$34 \$35 \$37 pd[0][7] SP6T1Dec_and3_x1
X$13 vdd vss \$30 \$31 \$39 \$33 page[4] SP6T1Dec_and4_x1
X$16 vdd vss \$36 \$31 \$39 \$33 page[5] SP6T1Dec_and4_x1
X$19 vdd vss \$30 \$38 \$39 \$33 page[6] SP6T1Dec_and4_x1
X$22 vdd vss \$36 \$38 \$39 \$33 page[7] SP6T1Dec_and4_x1
X$25 vdd vss \$30 \$31 \$32 \$48 page[8] SP6T1Dec_and4_x1
X$28 vdd vss \$36 \$31 \$32 \$48 page[9] SP6T1Dec_and4_x1
X$31 vdd vss \$30 \$38 \$32 \$48 page[10] SP6T1Dec_and4_x1
X$33 vdd vss \$36 \$38 \$32 \$48 page[11] SP6T1Dec_and4_x1
X$36 vdd vss \$30 \$31 \$39 \$48 page[12] SP6T1Dec_and4_x1
X$39 vdd vss \$36 \$31 \$39 \$48 page[13] SP6T1Dec_and4_x1
X$42 vdd vss \$30 \$38 \$39 \$48 page[14] SP6T1Dec_and4_x1
X$45 vdd vss \$36 \$38 \$39 \$48 page[15] SP6T1Dec_and4_x1
X$47 vss a[0] \$34 clk vdd SP6T1Dec_dff_x1
X$48 vss vdd \$27 \$34 SP6T1Dec_inv_x1
X$49 vss a[1] \$35 clk vdd SP6T1Dec_dff_x1
X$50 vss vdd \$28 \$35 SP6T1Dec_inv_x1
X$51 vss a[2] \$37 clk vdd SP6T1Dec_dff_x1
X$52 vss vdd \$29 \$37 SP6T1Dec_inv_x1
X$53 vss a[3] \$36 clk vdd SP6T1Dec_dff_x1
X$54 vss vdd \$30 \$36 SP6T1Dec_inv_x1
X$55 vss a[4] \$38 clk vdd SP6T1Dec_dff_x1
X$56 vss vdd \$31 \$38 SP6T1Dec_inv_x1
X$57 vss a[5] \$39 clk vdd SP6T1Dec_dff_x1
X$58 vss vdd \$32 \$39 SP6T1Dec_inv_x1
X$59 vss a[6] \$48 clk vdd SP6T1Dec_dff_x1
X$60 vss vdd \$33 \$48 SP6T1Dec_inv_x1
.ENDS SP6T2RowPredecoders_A3B4B

.SUBCKT SP6T1Dec_inv_x2 vss vdd nq i
M$1 vss i nq vss sg13_lv_nmos L=0.13u W=5.6u AS=1.484p AD=1.484p PS=9.46u
+ PD=9.46u
M$3 vdd i nq vdd sg13_lv_pmos L=0.13u W=8.8u AS=2.332p AD=2.332p PS=14.26u
+ PD=14.26u
.ENDS SP6T1Dec_inv_x2

.SUBCKT SP6T1Dec_nand2_x0 vss vdd i0 nq i1
M$1 vss i0 \$6 vss sg13_lv_nmos L=0.13u W=0.78u AS=0.2652p AD=0.1482p PS=2.24u
+ PD=1.16u
M$2 \$6 i1 nq vss sg13_lv_nmos L=0.13u W=0.78u AS=0.1482p AD=0.312p PS=1.16u
+ PD=2.36u
M$3 vdd i0 nq vdd sg13_lv_pmos L=0.13u W=1.2u AS=0.408p AD=0.228p PS=3.08u
+ PD=1.58u
M$4 nq i1 vdd vdd sg13_lv_pmos L=0.13u W=1.2u AS=0.228p AD=0.48p PS=1.58u
+ PD=3.2u
.ENDS SP6T1Dec_nand2_x0

.SUBCKT SP6T2Array_64X32 vss bl[0] bl_n[0] bl_n[1] bl[1] bl[2] bl_n[2] bl_n[3]
+ bl[3] bl[4] bl_n[4] bl_n[5] bl[5] bl[6] bl_n[6] bl_n[7] bl[7] bl[8] bl_n[8]
+ bl_n[9] bl[9] bl[10] bl_n[10] bl_n[11] bl[11] bl[12] bl_n[12] bl_n[13] bl[13]
+ bl[14] bl_n[14] bl_n[15] bl[15] wl[26] wl[16] wl[31] wl[30] wl[29] wl[28]
+ wl[17] wl[27] wl[20] wl[18] wl[25] wl[24] wl[23] wl[19] wl[22] wl[21] vdd
+ wl[0] wl[1] wl[2] wl[3] wl[4] wl[5] wl[6] wl[7] wl[8] wl[9] wl[10] wl[11]
+ wl[12] wl[13] wl[14] wl[15] bl[16] bl_n[16] bl_n[17] bl[17] bl[18] bl_n[18]
+ bl_n[19] bl[19] bl[20] bl_n[20] bl_n[21] bl[21] bl[22] bl_n[22] bl_n[23]
+ bl[23] bl[24] bl_n[24] bl_n[25] bl[25] bl[26] bl_n[26] bl_n[27] bl[27] bl[28]
+ bl_n[28] bl_n[29] bl[29] bl[30] bl_n[30] bl_n[31] bl[31] wl[50] wl[32] wl[51]
+ wl[52] wl[53] wl[54] wl[55] wl[56] wl[57] wl[58] wl[59] wl[60] wl[61] wl[62]
+ wl[47] wl[41] wl[43] wl[40] wl[44] wl[39] wl[45] wl[38] wl[46] wl[37] wl[42]
+ wl[36] wl[35] wl[34] wl[48] wl[33] wl[49] wl[63]
X$2 vss bl[0] bl_n[0] bl_n[1] bl[1] bl[2] bl_n[2] bl_n[3] bl[3] bl[4] bl_n[4]
+ bl_n[5] bl[5] bl[6] bl_n[6] bl_n[7] bl[7] bl[8] bl_n[8] bl_n[9] bl[9] bl[10]
+ bl_n[10] bl_n[11] bl[11] bl[12] bl_n[12] bl_n[13] bl[13] bl[14] bl_n[14]
+ bl_n[15] bl[15] wl[7] wl[8] wl[6] wl[9] wl[5] wl[10] wl[4] wl[11] wl[3] wl[2]
+ wl[1] wl[0] wl[12] wl[13] wl[14] wl[15] bl[16] bl_n[16] bl_n[17] bl[17]
+ bl[18] bl_n[18] bl_n[19] bl[19] bl[20] bl_n[20] bl_n[21] bl[21] bl[22]
+ bl_n[22] bl_n[23] bl[23] bl[24] bl_n[24] bl_n[25] bl[25] bl[26] bl_n[26]
+ bl_n[27] bl[27] bl[28] bl_n[28] bl_n[29] bl[29] bl[30] bl_n[30] bl_n[31]
+ bl[31] wl[31] wl[30] wl[29] wl[28] wl[27] wl[26] wl[25] vdd wl[16] wl[24]
+ wl[17] wl[18] wl[19] wl[20] wl[21] wl[22] wl[23] SP6T2Array_32X32
X$3 vss bl[0] bl_n[0] bl_n[1] bl[1] bl[2] bl_n[2] bl_n[3] bl[3] bl[4] bl_n[4]
+ bl_n[5] bl[5] bl[6] bl_n[6] bl_n[7] bl[7] bl[8] bl_n[8] bl_n[9] bl[9] bl[10]
+ bl_n[10] bl_n[11] bl[11] bl[12] bl_n[12] bl_n[13] bl[13] bl[14] bl_n[14]
+ bl_n[15] bl[15] wl[39] wl[40] wl[38] wl[41] wl[37] wl[42] wl[36] wl[43]
+ wl[35] wl[34] wl[33] wl[32] wl[44] wl[45] wl[46] wl[47] bl[16] bl_n[16]
+ bl_n[17] bl[17] bl[18] bl_n[18] bl_n[19] bl[19] bl[20] bl_n[20] bl_n[21]
+ bl[21] bl[22] bl_n[22] bl_n[23] bl[23] bl[24] bl_n[24] bl_n[25] bl[25] bl[26]
+ bl_n[26] bl_n[27] bl[27] bl[28] bl_n[28] bl_n[29] bl[29] bl[30] bl_n[30]
+ bl_n[31] bl[31] wl[63] wl[62] wl[61] wl[60] wl[59] wl[58] wl[57] vdd wl[48]
+ wl[56] wl[49] wl[50] wl[51] wl[52] wl[53] wl[54] wl[55] SP6T2Array_32X32
.ENDS SP6T2Array_64X32

.SUBCKT SP6T2Precharge_26L100W precharge_n bl bl_n vdd nwell
M$1 vdd precharge_n bl nwell sg13_lv_pmos L=0.13u W=0.5u AS=0.375p AD=0.29875p
+ PS=2.5u PD=1.695u
M$2 bl precharge_n bl_n nwell sg13_lv_pmos L=0.13u W=0.5u AS=0.29875p
+ AD=0.29875p PS=1.695u PD=1.695u
M$3 bl_n precharge_n vdd nwell sg13_lv_pmos L=0.13u W=0.5u AS=0.29875p
+ AD=0.375p PS=1.695u PD=2.5u
.ENDS SP6T2Precharge_26L100W

.SUBCKT SP6T2ColMux_4MN26L580W1R vss muxbl bl[0] bl_n[0] muxbl_n bl_n[1] bl[1]
+ bl[2] bl_n[2] bl_n[3] bl[3] mux[0] mux[1] mux[2] mux[3]
M$1 bl[3] mux[3] muxbl vss sg13_lv_nmos L=0.13u W=2.9u AS=0.986p AD=0.986p
+ PS=6.48u PD=6.48u
M$2 bl_n[2] mux[2] muxbl_n vss sg13_lv_nmos L=0.13u W=2.9u AS=0.986p AD=0.551p
+ PS=6.48u PD=3.28u
M$3 muxbl_n mux[3] bl_n[3] vss sg13_lv_nmos L=0.13u W=2.9u AS=0.551p AD=0.986p
+ PS=3.28u PD=6.48u
M$4 bl[1] mux[1] muxbl vss sg13_lv_nmos L=0.13u W=2.9u AS=0.986p AD=0.551p
+ PS=6.48u PD=3.28u
M$5 muxbl mux[2] bl[2] vss sg13_lv_nmos L=0.13u W=2.9u AS=0.551p AD=0.986p
+ PS=3.28u PD=6.48u
M$6 bl_n[0] mux[0] muxbl_n vss sg13_lv_nmos L=0.13u W=2.9u AS=0.986p AD=0.551p
+ PS=6.48u PD=3.28u
M$7 muxbl_n mux[1] bl_n[1] vss sg13_lv_nmos L=0.13u W=2.9u AS=0.551p AD=0.986p
+ PS=3.28u PD=6.48u
M$8 muxbl mux[0] bl[0] vss sg13_lv_nmos L=0.13u W=2.9u AS=0.986p AD=0.986p
+ PS=6.48u PD=6.48u
.ENDS SP6T2ColMux_4MN26L580W1R

.SUBCKT SP6T2ReadWrite_CM4MN26L580W1R_WD26L380W bl vss bl_n vdd q d clk we_n
X$1 q vdd vss bl_n bl nsnrlatch_x1
X$2 vss vdd \$5 \$16 we_n nor2_x0
X$3 vss vdd \$16 \$11 inv_x0
X$4 vss d \$11 clk vdd dff_x1
X$5 vss vdd \$3 \$11 we_n nor2_x0
M$1 bl \$3 vss vss sg13_lv_nmos L=0.13u W=1.9u AS=0.5074p AD=0.361p PS=4.48u
+ PD=2.28u
M$2 vss \$5 bl_n vss sg13_lv_nmos L=0.13u W=1.9u AS=0.361p AD=0.5074p PS=2.28u
+ PD=4.48u
.ENDS SP6T2ReadWrite_CM4MN26L580W1R_WD26L380W

.SUBCKT SP6T2ClockWE clkup we we_en we_n vss vdd clkdown
X$1 vdd vss clkup clkdown buf_x2
X$2 vss we \$9 clkdown vdd dff_x1
X$3 vss vdd \$9 we_n we_en nand2_x0
.ENDS SP6T2ClockWE

.SUBCKT SP6T2RowDecoderNand3X2 vss vdd wl_n[0] wl_en pd[0][0] page wl_n[1]
+ pd[0][1]
M$1 wl_n[0] wl_en \$12 vss sg13_lv_nmos L=0.13u W=0.49u AS=0.1666p AD=0.1078p
+ PS=1.66u PD=0.93u
M$2 \$12 pd[0][0] \$11 vss sg13_lv_nmos L=0.13u W=0.49u AS=0.1078p AD=0.1078p
+ PS=0.93u PD=0.93u
M$3 vss page \$11 vss sg13_lv_nmos L=0.13u W=0.49u AS=0.1708p AD=0.1078p
+ PS=1.35u PD=0.93u
M$4 vss page \$10 vss sg13_lv_nmos L=0.13u W=0.49u AS=0.1708p AD=0.1078p
+ PS=1.35u PD=0.93u
M$5 \$10 pd[0][1] \$9 vss sg13_lv_nmos L=0.13u W=0.49u AS=0.1078p AD=0.1078p
+ PS=0.93u PD=0.93u
M$6 \$9 wl_en wl_n[1] vss sg13_lv_nmos L=0.13u W=0.49u AS=0.1078p AD=0.1666p
+ PS=0.93u PD=1.66u
M$7 wl_n[0] wl_en vdd vdd sg13_lv_pmos L=0.13u W=0.49u AS=0.1666p AD=0.1708p
+ PS=1.66u PD=1.35u
M$8 vdd pd[0][0] wl_n[0] vdd sg13_lv_pmos L=0.13u W=0.49u AS=0.1708p AD=0.1078p
+ PS=1.35u PD=0.93u
M$9 wl_n[0] page vdd vdd sg13_lv_pmos L=0.13u W=0.49u AS=0.1078p AD=0.1708p
+ PS=0.93u PD=1.35u
M$10 vdd page wl_n[1] vdd sg13_lv_pmos L=0.13u W=0.49u AS=0.1708p AD=0.1078p
+ PS=1.35u PD=0.93u
M$11 wl_n[1] pd[0][1] vdd vdd sg13_lv_pmos L=0.13u W=0.49u AS=0.1078p
+ AD=0.1708p PS=0.93u PD=1.35u
M$12 vdd wl_en wl_n[1] vdd sg13_lv_pmos L=0.13u W=0.49u AS=0.1708p AD=0.1666p
+ PS=1.35u PD=1.66u
.ENDS SP6T2RowDecoderNand3X2

.SUBCKT SP6T1Dec_and4_x1 vdd vss i0 i1 i2 i3 q
M$1 \$1 i0 \$11 vss sg13_lv_nmos L=0.13u W=0.78u AS=0.2652p AD=0.1482p PS=2.24u
+ PD=1.16u
M$2 \$11 i1 \$10 vss sg13_lv_nmos L=0.13u W=0.78u AS=0.1482p AD=0.1482p
+ PS=1.16u PD=1.16u
M$3 \$10 i2 \$9 vss sg13_lv_nmos L=0.13u W=0.78u AS=0.1482p AD=0.1482p PS=1.16u
+ PD=1.16u
M$4 \$9 i3 vss vss sg13_lv_nmos L=0.13u W=0.78u AS=0.1482p AD=0.5033p PS=1.16u
+ PD=3.21u
M$5 vss \$1 q vss sg13_lv_nmos L=0.13u W=2.8u AS=0.5033p AD=1.036p PS=3.21u
+ PD=6.34u
M$6 vdd i0 \$1 vdd sg13_lv_pmos L=0.13u W=1.2u AS=0.408p AD=0.228p PS=3.08u
+ PD=1.58u
M$7 \$1 i1 vdd vdd sg13_lv_pmos L=0.13u W=1.2u AS=0.228p AD=0.228p PS=1.58u
+ PD=1.58u
M$8 vdd i2 \$1 vdd sg13_lv_pmos L=0.13u W=1.2u AS=0.228p AD=0.228p PS=1.58u
+ PD=1.58u
M$9 vdd i3 \$1 vdd sg13_lv_pmos L=0.13u W=1.2u AS=0.79p AD=0.228p PS=4.81u
+ PD=1.58u
M$10 vdd \$1 q vdd sg13_lv_pmos L=0.13u W=4.4u AS=0.79p AD=1.628p PS=4.81u
+ PD=9.54u
.ENDS SP6T1Dec_and4_x1

.SUBCKT SP6T1Dec_and3_x1 vdd vss i0 i1 i2 q
M$1 \$1 i0 \$9 vss sg13_lv_nmos L=0.13u W=0.78u AS=0.2652p AD=0.1482p PS=2.24u
+ PD=1.16u
M$2 \$9 i1 \$8 vss sg13_lv_nmos L=0.13u W=0.78u AS=0.1482p AD=0.1482p PS=1.16u
+ PD=1.16u
M$3 \$8 i2 vss vss sg13_lv_nmos L=0.13u W=0.78u AS=0.1482p AD=0.5033p PS=1.16u
+ PD=3.21u
M$4 vss \$1 q vss sg13_lv_nmos L=0.13u W=2.8u AS=0.5033p AD=1.036p PS=3.21u
+ PD=6.34u
M$5 \$1 i0 vdd vdd sg13_lv_pmos L=0.13u W=1.2u AS=0.408p AD=0.228p PS=3.08u
+ PD=1.58u
M$6 vdd i1 \$1 vdd sg13_lv_pmos L=0.13u W=1.2u AS=0.228p AD=0.228p PS=1.58u
+ PD=1.58u
M$7 vdd i2 \$1 vdd sg13_lv_pmos L=0.13u W=1.2u AS=0.79p AD=0.228p PS=4.81u
+ PD=1.58u
M$8 vdd \$1 q vdd sg13_lv_pmos L=0.13u W=4.4u AS=0.79p AD=1.628p PS=4.81u
+ PD=9.54u
.ENDS SP6T1Dec_and3_x1

.SUBCKT SP6T1Dec_inv_x1 vss vdd nq i
M$1 vss i nq vss sg13_lv_nmos L=0.13u W=2.8u AS=0.952p AD=0.952p PS=6.28u
+ PD=6.28u
M$2 vdd i nq vdd sg13_lv_pmos L=0.13u W=4.4u AS=1.496p AD=1.496p PS=9.48u
+ PD=9.48u
.ENDS SP6T1Dec_inv_x1

.SUBCKT SP6T1Dec_dff_x1 vss i q clk vdd
M$1 \$4 i vss vss sg13_lv_nmos L=0.13u W=0.78u AS=0.2652p AD=0.1482p PS=2.24u
+ PD=1.16u
M$2 vss \$4 \$11 vss sg13_lv_nmos L=0.13u W=0.78u AS=0.1482p AD=0.1482p
+ PS=1.16u PD=1.16u
M$3 \$11 \$2 \$6 vss sg13_lv_nmos L=0.13u W=0.78u AS=0.1482p AD=0.1482p
+ PS=1.16u PD=1.16u
M$4 \$6 \$3 \$12 vss sg13_lv_nmos L=0.13u W=0.78u AS=0.1482p AD=0.1482p
+ PS=1.16u PD=1.16u
M$5 \$12 \$7 vss vss sg13_lv_nmos L=0.13u W=0.78u AS=0.1482p AD=0.1638p
+ PS=1.16u PD=1.2u
M$6 vss \$6 \$7 vss sg13_lv_nmos L=0.13u W=0.78u AS=0.1638p AD=0.2496p PS=1.2u
+ PD=1.42u
M$7 \$7 \$3 \$8 vss sg13_lv_nmos L=0.13u W=0.78u AS=0.2496p AD=0.1482p PS=1.42u
+ PD=1.16u
M$8 \$8 \$2 \$10 vss sg13_lv_nmos L=0.13u W=0.78u AS=0.1482p AD=0.1482p
+ PS=1.16u PD=1.16u
M$9 \$10 q vss vss sg13_lv_nmos L=0.13u W=0.78u AS=0.1482p AD=0.7217p PS=1.16u
+ PD=2.88u
M$10 vss \$8 q vss sg13_lv_nmos L=0.13u W=2.17u AS=0.7217p AD=0.7378p PS=2.88u
+ PD=5.02u
M$11 \$2 clk vss vss sg13_lv_nmos L=0.13u W=0.78u AS=0.2652p AD=0.1716p
+ PS=2.24u PD=1.22u
M$12 vss \$2 \$3 vss sg13_lv_nmos L=0.13u W=0.78u AS=0.1716p AD=0.2652p
+ PS=1.22u PD=2.24u
M$13 \$2 clk vdd vdd sg13_lv_pmos L=0.13u W=1.2u AS=0.408p AD=0.264p PS=3.08u
+ PD=1.64u
M$14 vdd \$2 \$3 vdd sg13_lv_pmos L=0.13u W=1.2u AS=0.264p AD=0.408p PS=1.64u
+ PD=3.08u
M$15 \$4 i vdd vdd sg13_lv_pmos L=0.13u W=1.2u AS=0.408p AD=0.228p PS=3.08u
+ PD=1.58u
M$16 vdd \$4 \$15 vdd sg13_lv_pmos L=0.13u W=1.2u AS=0.228p AD=0.228p PS=1.58u
+ PD=1.58u
M$17 \$15 \$3 \$6 vdd sg13_lv_pmos L=0.13u W=1.2u AS=0.228p AD=0.228p PS=1.58u
+ PD=1.58u
M$18 \$6 \$2 \$16 vdd sg13_lv_pmos L=0.13u W=1.2u AS=0.228p AD=0.228p PS=1.58u
+ PD=1.58u
M$19 \$16 \$7 vdd vdd sg13_lv_pmos L=0.13u W=1.2u AS=0.228p AD=0.252p PS=1.58u
+ PD=1.62u
M$20 vdd \$6 \$7 vdd sg13_lv_pmos L=0.13u W=1.2u AS=0.252p AD=0.384p PS=1.62u
+ PD=1.84u
M$21 \$7 \$2 \$8 vdd sg13_lv_pmos L=0.13u W=1.2u AS=0.384p AD=0.228p PS=1.84u
+ PD=1.58u
M$22 \$8 \$3 \$17 vdd sg13_lv_pmos L=0.13u W=1.2u AS=0.228p AD=0.228p PS=1.58u
+ PD=1.58u
M$23 vdd q \$17 vdd sg13_lv_pmos L=0.13u W=1.2u AS=1.2484p AD=0.228p PS=4.48u
+ PD=1.58u
M$24 vdd \$8 q vdd sg13_lv_pmos L=0.13u W=3.77u AS=1.2484p AD=1.2818p PS=4.48u
+ PD=8.22u
.ENDS SP6T1Dec_dff_x1

.SUBCKT SP6T2Array_32X32 vss bl[0] bl_n[0] bl_n[1] bl[1] bl[2] bl_n[2] bl_n[3]
+ bl[3] bl[4] bl_n[4] bl_n[5] bl[5] bl[6] bl_n[6] bl_n[7] bl[7] bl[8] bl_n[8]
+ bl_n[9] bl[9] bl[10] bl_n[10] bl_n[11] bl[11] bl[12] bl_n[12] bl_n[13] bl[13]
+ bl[14] bl_n[14] bl_n[15] bl[15] wl[7] wl[8] wl[6] wl[9] wl[5] wl[10] wl[4]
+ wl[11] wl[3] wl[2] wl[1] wl[0] wl[12] wl[13] wl[14] wl[15] bl[16] bl_n[16]
+ bl_n[17] bl[17] bl[18] bl_n[18] bl_n[19] bl[19] bl[20] bl_n[20] bl_n[21]
+ bl[21] bl[22] bl_n[22] bl_n[23] bl[23] bl[24] bl_n[24] bl_n[25] bl[25] bl[26]
+ bl_n[26] bl_n[27] bl[27] bl[28] bl_n[28] bl_n[29] bl[29] bl[30] bl_n[30]
+ bl_n[31] bl[31] wl[31] wl[30] wl[29] wl[28] wl[27] wl[26] wl[25] vdd wl[16]
+ wl[24] wl[17] wl[18] wl[19] wl[20] wl[21] wl[22] wl[23]
X$1 vss vss bl[0] vdd vdd bl_n[0] bl_n[1] bl[1] bl[2] bl_n[2] bl_n[3] bl[3]
+ bl[4] bl_n[4] bl_n[5] bl[5] bl[6] bl_n[6] bl_n[7] bl[7] bl[8] bl_n[8] bl_n[9]
+ bl[9] bl[10] bl_n[10] bl_n[11] bl[11] bl[12] bl_n[12] bl_n[13] bl[13] bl[14]
+ bl_n[14] bl_n[15] bl[15] wl[2] wl[1] wl[0] wl[3] wl[4] wl[5] wl[6] wl[7]
+ bl[16] bl_n[16] bl_n[17] bl[17] bl[18] bl_n[18] bl_n[19] bl[19] bl[20]
+ bl_n[20] bl_n[21] bl[21] bl[22] bl_n[22] bl_n[23] bl[23] bl[24] bl_n[24]
+ bl_n[25] bl[25] bl[26] bl_n[26] bl_n[27] bl[27] bl[28] bl_n[28] bl_n[29]
+ bl[29] bl[30] bl_n[30] bl_n[31] bl[31] wl[15] wl[8] wl[9] wl[10] wl[11]
+ wl[14] wl[13] wl[12] SP6T2Array_16X32
X$3 vss vss bl[0] vdd vdd bl_n[0] bl_n[1] bl[1] bl[2] bl_n[2] bl_n[3] bl[3]
+ bl[4] bl_n[4] bl_n[5] bl[5] bl[6] bl_n[6] bl_n[7] bl[7] bl[8] bl_n[8] bl_n[9]
+ bl[9] bl[10] bl_n[10] bl_n[11] bl[11] bl[12] bl_n[12] bl_n[13] bl[13] bl[14]
+ bl_n[14] bl_n[15] bl[15] wl[18] wl[17] wl[16] wl[19] wl[20] wl[21] wl[22]
+ wl[23] bl[16] bl_n[16] bl_n[17] bl[17] bl[18] bl_n[18] bl_n[19] bl[19] bl[20]
+ bl_n[20] bl_n[21] bl[21] bl[22] bl_n[22] bl_n[23] bl[23] bl[24] bl_n[24]
+ bl_n[25] bl[25] bl[26] bl_n[26] bl_n[27] bl[27] bl[28] bl_n[28] bl_n[29]
+ bl[29] bl[30] bl_n[30] bl_n[31] bl[31] wl[31] wl[24] wl[25] wl[26] wl[27]
+ wl[30] wl[29] wl[28] SP6T2Array_16X32
.ENDS SP6T2Array_32X32

.SUBCKT inv_x0 vss vdd nq i
M$1 vss i nq vss sg13_lv_nmos L=0.13u W=0.78u AS=0.2652p AD=0.2652p PS=2.24u
+ PD=2.24u
M$2 vdd i nq vdd sg13_lv_pmos L=0.13u W=0.78u AS=0.2652p AD=0.2652p PS=2.24u
+ PD=2.24u
.ENDS inv_x0

.SUBCKT nor2_x0 vss vdd nq i0 i1
M$1 vss i0 nq vss sg13_lv_nmos L=0.13u W=0.78u AS=0.2652p AD=0.1482p PS=2.24u
+ PD=1.16u
M$2 nq i1 vss vss sg13_lv_nmos L=0.13u W=0.78u AS=0.1482p AD=0.2808p PS=1.16u
+ PD=2.28u
M$3 vdd i0 \$6 vdd sg13_lv_pmos L=0.13u W=0.78u AS=0.2652p AD=0.1482p PS=2.24u
+ PD=1.16u
M$4 \$6 i1 nq vdd sg13_lv_pmos L=0.13u W=0.78u AS=0.1482p AD=0.2808p PS=1.16u
+ PD=2.28u
.ENDS nor2_x0

.SUBCKT nsnrlatch_x1 q vdd vss nset nrst
M$1 q nset \$8 vss sg13_lv_nmos L=0.13u W=1.31u AS=0.4454p AD=0.2489p PS=3.3u
+ PD=1.69u
M$2 \$8 nq vss vss sg13_lv_nmos L=0.13u W=1.31u AS=0.2489p AD=0.2489p PS=1.69u
+ PD=1.69u
M$3 vss q \$7 vss sg13_lv_nmos L=0.13u W=1.31u AS=0.2489p AD=0.262p PS=1.69u
+ PD=1.71u
M$4 \$7 nrst nq vss sg13_lv_nmos L=0.13u W=1.31u AS=0.262p AD=0.4454p PS=1.71u
+ PD=3.3u
M$5 vdd nset q vdd sg13_lv_pmos L=0.13u W=1.3u AS=0.442p AD=0.247p PS=3.28u
+ PD=1.68u
M$6 q nq vdd vdd sg13_lv_pmos L=0.13u W=1.3u AS=0.247p AD=0.247p PS=1.68u
+ PD=1.68u
M$7 vdd q nq vdd sg13_lv_pmos L=0.13u W=1.3u AS=0.247p AD=0.26p PS=1.68u PD=1.7u
M$8 nq nrst vdd vdd sg13_lv_pmos L=0.13u W=1.3u AS=0.26p AD=0.442p PS=1.7u
+ PD=3.28u
.ENDS nsnrlatch_x1

.SUBCKT nand2_x0 vss vdd i0 nq i1
M$1 vss i0 \$6 vss sg13_lv_nmos L=0.13u W=0.78u AS=0.2652p AD=0.1482p PS=2.24u
+ PD=1.16u
M$2 \$6 i1 nq vss sg13_lv_nmos L=0.13u W=0.78u AS=0.1482p AD=0.2808p PS=1.16u
+ PD=2.28u
M$3 vdd i0 nq vdd sg13_lv_pmos L=0.13u W=0.78u AS=0.2652p AD=0.1482p PS=2.24u
+ PD=1.16u
M$4 nq i1 vdd vdd sg13_lv_pmos L=0.13u W=0.78u AS=0.1482p AD=0.2808p PS=1.16u
+ PD=2.28u
.ENDS nand2_x0

.SUBCKT dff_x1 vss i q clk vdd
M$1 \$4 i vss vss sg13_lv_nmos L=0.13u W=0.78u AS=0.2652p AD=0.1482p PS=2.24u
+ PD=1.16u
M$2 vss \$4 \$12 vss sg13_lv_nmos L=0.13u W=0.78u AS=0.1482p AD=0.1482p
+ PS=1.16u PD=1.16u
M$3 \$12 \$2 \$6 vss sg13_lv_nmos L=0.13u W=0.78u AS=0.1482p AD=0.1482p
+ PS=1.16u PD=1.16u
M$4 \$6 \$3 \$11 vss sg13_lv_nmos L=0.13u W=0.78u AS=0.1482p AD=0.1482p
+ PS=1.16u PD=1.16u
M$5 \$11 \$7 vss vss sg13_lv_nmos L=0.13u W=0.78u AS=0.1482p AD=0.1482p
+ PS=1.16u PD=1.16u
M$6 vss \$6 \$7 vss sg13_lv_nmos L=0.13u W=0.78u AS=0.1482p AD=0.2028p PS=1.16u
+ PD=1.3u
M$7 \$7 \$3 \$8 vss sg13_lv_nmos L=0.13u W=0.78u AS=0.2028p AD=0.1482p PS=1.3u
+ PD=1.16u
M$8 \$8 \$2 \$10 vss sg13_lv_nmos L=0.13u W=0.78u AS=0.1482p AD=0.1482p
+ PS=1.16u PD=1.16u
M$9 \$10 q vss vss sg13_lv_nmos L=0.13u W=0.78u AS=0.1482p AD=0.2265p PS=1.16u
+ PD=1.38u
M$10 vss \$8 q vss sg13_lv_nmos L=0.13u W=0.83u AS=0.2265p AD=0.2822p PS=1.38u
+ PD=2.34u
M$11 \$2 clk vss vss sg13_lv_nmos L=0.13u W=0.78u AS=0.2652p AD=0.156p PS=2.24u
+ PD=1.18u
M$12 vss \$2 \$3 vss sg13_lv_nmos L=0.13u W=0.78u AS=0.156p AD=0.2652p PS=1.18u
+ PD=2.24u
M$13 \$2 clk vdd vdd sg13_lv_pmos L=0.13u W=0.78u AS=0.2652p AD=0.156p PS=2.24u
+ PD=1.18u
M$14 vdd \$2 \$3 vdd sg13_lv_pmos L=0.13u W=0.78u AS=0.156p AD=0.2652p PS=1.18u
+ PD=2.24u
M$15 \$4 i vdd vdd sg13_lv_pmos L=0.13u W=0.78u AS=0.2652p AD=0.1482p PS=2.24u
+ PD=1.16u
M$16 vdd \$4 \$15 vdd sg13_lv_pmos L=0.13u W=0.78u AS=0.1482p AD=0.1482p
+ PS=1.16u PD=1.16u
M$17 \$15 \$3 \$6 vdd sg13_lv_pmos L=0.13u W=0.78u AS=0.1482p AD=0.1482p
+ PS=1.16u PD=1.16u
M$18 \$6 \$2 \$16 vdd sg13_lv_pmos L=0.13u W=0.78u AS=0.1482p AD=0.1482p
+ PS=1.16u PD=1.16u
M$19 \$16 \$7 vdd vdd sg13_lv_pmos L=0.13u W=0.78u AS=0.1482p AD=0.1482p
+ PS=1.16u PD=1.16u
M$20 vdd \$6 \$7 vdd sg13_lv_pmos L=0.13u W=0.78u AS=0.1482p AD=0.2028p
+ PS=1.16u PD=1.3u
M$21 \$7 \$2 \$8 vdd sg13_lv_pmos L=0.13u W=0.78u AS=0.2028p AD=0.1482p PS=1.3u
+ PD=1.16u
M$22 \$8 \$3 \$17 vdd sg13_lv_pmos L=0.13u W=0.78u AS=0.1482p AD=0.1482p
+ PS=1.16u PD=1.16u
M$23 vdd q \$17 vdd sg13_lv_pmos L=0.13u W=0.78u AS=0.2241p AD=0.1482p PS=1.37u
+ PD=1.16u
M$24 vdd \$8 q vdd sg13_lv_pmos L=0.13u W=0.82u AS=0.2241p AD=0.2788p PS=1.37u
+ PD=2.32u
.ENDS dff_x1

.SUBCKT buf_x2 vdd vss i q
M$1 \$1 i vss vss sg13_lv_nmos L=0.13u W=0.78u AS=0.2652p AD=0.2092p PS=2.24u
+ PD=1.48u
M$2 vss \$1 q vss sg13_lv_nmos L=0.13u W=2.14u AS=0.4125p AD=0.5671p PS=2.93u
+ PD=4.27u
M$4 vdd i \$1 vdd sg13_lv_pmos L=0.13u W=0.78u AS=0.2075p AD=0.2652p PS=1.47u
+ PD=2.24u
M$5 vdd \$1 q vdd sg13_lv_pmos L=0.13u W=2.12u AS=0.4089p AD=0.5618p PS=2.91u
+ PD=4.24u
.ENDS buf_x2

.SUBCKT SP6T2Array_16X32 \$1 vss bl[0] vdd nwell bl_n[0] bl_n[1] bl[1] bl[2]
+ bl_n[2] bl_n[3] bl[3] bl[4] bl_n[4] bl_n[5] bl[5] bl[6] bl_n[6] bl_n[7] bl[7]
+ bl[8] bl_n[8] bl_n[9] bl[9] bl[10] bl_n[10] bl_n[11] bl[11] bl[12] bl_n[12]
+ bl_n[13] bl[13] bl[14] bl_n[14] bl_n[15] bl[15] wl[2] wl[1] wl[0] wl[3] wl[4]
+ wl[5] wl[6] wl[7] bl[16] bl_n[16] bl_n[17] bl[17] bl[18] bl_n[18] bl_n[19]
+ bl[19] bl[20] bl_n[20] bl_n[21] bl[21] bl[22] bl_n[22] bl_n[23] bl[23] bl[24]
+ bl_n[24] bl_n[25] bl[25] bl[26] bl_n[26] bl_n[27] bl[27] bl[28] bl_n[28]
+ bl_n[29] bl[29] bl[30] bl_n[30] bl_n[31] bl[31] wl[15] wl[8] wl[9] wl[10]
+ wl[11] wl[14] wl[13] wl[12]
X$1 \$1 vss bl[16] nwell vdd bl_n[16] bl_n[17] bl[17] bl[18] bl_n[18] bl_n[19]
+ bl[19] bl[20] bl_n[20] bl_n[21] bl[21] bl[22] bl_n[22] bl_n[23] bl[23] wl[5]
+ wl[6] wl[4] wl[0] wl[1] wl[7] wl[2] wl[3] bl[24] bl_n[24] bl_n[25] bl[25]
+ bl[26] bl_n[26] bl_n[27] bl[27] bl[28] bl_n[28] bl_n[29] bl[29] bl[30]
+ bl_n[30] bl_n[31] bl[31] wl[8] wl[9] wl[10] wl[11] wl[12] wl[13] wl[14]
+ wl[15] SP6T2Array_16X16
X$2 \$1 vss bl[0] nwell vdd bl_n[0] bl_n[1] bl[1] bl[2] bl_n[2] bl_n[3] bl[3]
+ bl[4] bl_n[4] bl_n[5] bl[5] bl[6] bl_n[6] bl_n[7] bl[7] wl[5] wl[6] wl[4]
+ wl[0] wl[1] wl[7] wl[2] wl[3] bl[8] bl_n[8] bl_n[9] bl[9] bl[10] bl_n[10]
+ bl_n[11] bl[11] bl[12] bl_n[12] bl_n[13] bl[13] bl[14] bl_n[14] bl_n[15]
+ bl[15] wl[8] wl[9] wl[10] wl[11] wl[12] wl[13] wl[14] wl[15] SP6T2Array_16X16
.ENDS SP6T2Array_16X32

.SUBCKT SP6T2Array_16X16 \$1 vss bl[0] nwell vdd bl_n[0] bl_n[1] bl[1] bl[2]
+ bl_n[2] bl_n[3] bl[3] bl[4] bl_n[4] bl_n[5] bl[5] bl[6] bl_n[6] bl_n[7] bl[7]
+ wl[5] wl[6] wl[4] wl[0] wl[1] wl[7] wl[2] wl[3] bl[8] bl_n[8] bl_n[9] bl[9]
+ bl[10] bl_n[10] bl_n[11] bl[11] bl[12] bl_n[12] bl_n[13] bl[13] bl[14]
+ bl_n[14] bl_n[15] bl[15] wl[8] wl[9] wl[10] wl[11] wl[12] wl[13] wl[14] wl[15]
X$1 \$1 vss vdd wl[1] wl[7] wl[0] wl[2] wl[3] wl[4] wl[5] wl[6] bl[8] nwell
+ bl_n[8] bl_n[9] bl[9] bl[10] bl_n[10] bl_n[11] bl[11] wl[15] wl[9] wl[10]
+ wl[11] wl[12] wl[13] wl[14] wl[8] bl[12] bl_n[12] bl_n[13] bl[13] bl[14]
+ bl_n[14] bl_n[15] bl[15] SP6T2Array_16X8
X$2 \$1 vss vdd wl[1] wl[7] wl[0] wl[2] wl[3] wl[4] wl[5] wl[6] bl[0] nwell
+ bl_n[0] bl_n[1] bl[1] bl[2] bl_n[2] bl_n[3] bl[3] wl[15] wl[9] wl[10] wl[11]
+ wl[12] wl[13] wl[14] wl[8] bl[4] bl_n[4] bl_n[5] bl[5] bl[6] bl_n[6] bl_n[7]
+ bl[7] SP6T2Array_16X8
.ENDS SP6T2Array_16X16

.SUBCKT SP6T2Array_16X8 \$1 vss vdd wl[1] wl[7] wl[0] wl[2] wl[3] wl[4] wl[5]
+ wl[6] bl[0] nwell bl_n[0] bl_n[1] bl[1] bl[2] bl_n[2] bl_n[3] bl[3] wl[15]
+ wl[9] wl[10] wl[11] wl[12] wl[13] wl[14] wl[8] bl[4] bl_n[4] bl_n[5] bl[5]
+ bl[6] bl_n[6] bl_n[7] bl[7]
X$1 \$1 vss bl[0] nwell vdd bl_n[0] bl_n[1] bl[1] bl[2] bl_n[2] bl_n[3] bl[3]
+ wl[8] wl[9] wl[10] wl[11] bl[4] bl_n[4] bl_n[5] bl[5] bl[6] bl_n[6] bl_n[7]
+ bl[7] wl[12] wl[13] wl[14] wl[15] SP6T2Array_8X8
X$2 \$1 vss bl[0] nwell vdd bl_n[0] bl_n[1] bl[1] bl[2] bl_n[2] bl_n[3] bl[3]
+ wl[0] wl[1] wl[2] wl[3] bl[4] bl_n[4] bl_n[5] bl[5] bl[6] bl_n[6] bl_n[7]
+ bl[7] wl[4] wl[5] wl[6] wl[7] SP6T2Array_8X8
.ENDS SP6T2Array_16X8

.SUBCKT SP6T2Array_8X8 \$1 vss bl[0] nwell vdd bl_n[0] bl_n[1] bl[1] bl[2]
+ bl_n[2] bl_n[3] bl[3] wl[0] wl[1] wl[2] wl[3] bl[4] bl_n[4] bl_n[5] bl[5]
+ bl[6] bl_n[6] bl_n[7] bl[7] wl[4] wl[5] wl[6] wl[7]
X$1 vss vdd bl[4] bl_n[4] bl[5] bl_n[5] bl[6] bl_n[6] bl[7] bl_n[7] wl[0] wl[1]
+ wl[2] wl[3] wl[4] wl[5] wl[6] wl[7] nwell \$1 SP6T2Array_8X4
X$2 vss vdd bl[0] bl_n[0] bl[1] bl_n[1] bl[2] bl_n[2] bl[3] bl_n[3] wl[0] wl[1]
+ wl[2] wl[3] wl[4] wl[5] wl[6] wl[7] nwell \$1 SP6T2Array_8X4
.ENDS SP6T2Array_8X8

.SUBCKT SP6T2Array_8X4 vss vdd bl[0] bl_n[0] bl[1] bl_n[1] bl[2] bl_n[2] bl[3]
+ bl_n[3] wl[0] wl[1] wl[2] wl[3] wl[4] wl[5] wl[6] wl[7] nwell \$33
X$1 vss vdd bl[0] bl_n[0] bl[1] bl_n[1] bl[2] bl_n[2] bl[3] bl_n[3] wl[4] wl[5]
+ wl[6] wl[7] nwell \$33 SP6T2Array_4X4
X$2 vss vdd bl[0] bl_n[0] bl[1] bl_n[1] bl[2] bl_n[2] bl[3] bl_n[3] wl[0] wl[1]
+ wl[2] wl[3] nwell \$33 SP6T2Array_4X4
.ENDS SP6T2Array_8X4

.SUBCKT SP6T2Array_4X4 vss vdd bl[0] bl_n[0] bl[1] bl_n[1] bl[2] bl_n[2] bl[3]
+ bl_n[3] wl[0] wl[1] wl[2] wl[3] nwell \$29
X$1 vss vdd bl[2] bl_n[2] bl[3] bl_n[3] wl[0] wl[1] wl[2] wl[3] nwell \$29
+ SP6T2Array_4X2
X$2 vss vdd bl[0] bl_n[0] bl[1] bl_n[1] wl[0] wl[1] wl[2] wl[3] nwell \$29
+ SP6T2Array_4X2
.ENDS SP6T2Array_4X4

.SUBCKT SP6T2Array_4X2 vss vdd bl[0] bl_n[0] bl[1] bl_n[1] wl[0] wl[1] wl[2]
+ wl[3] nwell \$17
X$1 vss vdd bl[0] bl_n[0] bl[1] bl_n[1] wl[2] wl[3] nwell \$17 SP6T2Array_2X2
X$2 vss vdd bl[0] bl_n[0] bl[1] bl_n[1] wl[0] wl[1] nwell \$17 SP6T2Array_2X2
.ENDS SP6T2Array_4X2

.SUBCKT SP6T2Array_2X2 vss vdd bl[0] bl_n[0] bl[1] bl_n[1] wl[0] wl[1] nwell
+ \$15
X$1 vss vdd bl[1] bl_n[1] wl[0] wl[1] nwell \$15 SP6T2Array_2X1
X$2 vss vdd bl[0] bl_n[0] wl[0] wl[1] nwell \$15 SP6T2Array_2X1
.ENDS SP6T2Array_2X2

.SUBCKT SP6T2Array_2X1 vss vdd bl[0] bl_n[0] wl[0] wl[1] nwell \$9
X$1 bl[0] vss vdd bl_n[0] wl[1] nwell \$9 SP6T2Cell
X$2 bl[0] vss vdd bl_n[0] wl[0] nwell \$9 SP6T2Cell
.ENDS SP6T2Array_2X1

.SUBCKT SP6T2Cell bl vss vdd bl_n wl nwell \$10
M$1 vss \$1 \$5 \$10 sg13_lv_nmos L=0.13u W=0.55u AS=0.1445p AD=0.09325p
+ PS=1.68u PD=0.98u
M$2 \$5 wl bl_n \$10 sg13_lv_nmos L=0.13u W=0.3u AS=0.09325p AD=0.087p PS=0.98u
+ PD=1.18u
M$3 bl wl \$1 \$10 sg13_lv_nmos L=0.13u W=0.3u AS=0.087p AD=0.09325p PS=1.18u
+ PD=0.98u
M$4 \$1 \$5 vss \$10 sg13_lv_nmos L=0.13u W=0.55u AS=0.09325p AD=0.1445p
+ PS=0.98u PD=1.68u
M$5 \$1 \$5 vdd nwell sg13_lv_pmos L=0.13u W=0.55u AS=0.26675p AD=0.1595p
+ PS=2.07u PD=1.68u
M$6 vdd \$1 \$5 nwell sg13_lv_pmos L=0.13u W=0.55u AS=0.1595p AD=0.26675p
+ PS=1.68u PD=2.07u
.ENDS SP6T2Cell
